// Copyright lowRISC contributors (OpenTitan project).
// Licensed under the Apache License, Version 2.0, see LICENSE for details.
// SPDX-License-Identifier: Apache-2.0
//
// ------------------- W A R N I N G: A U T O - G E N E R A T E D   C O D E !! -------------------//
// PLEASE DO NOT HAND-EDIT THIS FILE. IT HAS BEEN AUTO-GENERATED WITH THE FOLLOWING COMMAND:
// util/topgen.py -t hw/top_peppermint/data/top_peppermint.hjson
//                -o hw/top_peppermint/
{
  seed:
  {
    topgen_seed:
    {
      seed_mode: testing
      value: 51451787542291517751888767411848989252412020777091149863881806945777355144337
    }
    otp_img_seed:
    {
      seed_mode: testing
      value: 24868028277047070845280224376993946593238997617476146683055290474876205000801
    }
    lc_ctrl_seed:
    {
      seed_mode: testing
      value: 49841089124658132456165265978197681960561948696349021308850918515200439523606
    }
  }
  module:
  [
    {
      name: otp_ctrl
      type: otp_ctrl
      base_addrs:
      {
        core:
        {
          hart: 0x40010000
        }
      }
      memory: {}
      param_list:
      [
        {
          name: RndCnstLfsrSeed
          desc: Compile-time random bits for initial LFSR seed
          type: otp_ctrl_top_specific_pkg::lfsr_seed_t
          randcount: 40
          randtype: data
          name_top: RndCnstOtpCtrlLfsrSeed
          default: 0xad6538f88a
          randwidth: 40
        }
        {
          name: RndCnstLfsrPerm
          desc: Compile-time random permutation for LFSR output
          type: otp_ctrl_top_specific_pkg::lfsr_perm_t
          randcount: 40
          randtype: perm
          name_top: RndCnstOtpCtrlLfsrPerm
          default: 0x90114d3070e568624e5e16de9c472355845f81259308a65d40b8942003e6
          randwidth: 240
        }
        {
          name: RndCnstScrmblKeyInit
          desc: Compile-time random permutation for scrambling key/nonce register reset value
          type: otp_ctrl_top_specific_pkg::scrmbl_key_init_t
          randcount: 256
          randtype: data
          name_top: RndCnstOtpCtrlScrmblKeyInit
          default: 0xa2d59d2b96f58961344a98a10f7a5dbb327bee2a376f9c3b86ee106ee6bc3ef8
          randwidth: 256
        }
        {
          name: RndCnstScrmblKey0
          desc: Compile-time scrambling key
          type: otp_ctrl_top_specific_pkg::key_t
          randcount: 128
          randtype: extdata
          name_top: RndCnstOtpCtrlScrmblKey0
          default: 0x98935387d84d189e94d201d4ca6d258f
          randwidth: 128
        }
        {
          name: RndCnstScrmblKey1
          desc: Compile-time scrambling key
          type: otp_ctrl_top_specific_pkg::key_t
          randcount: 128
          randtype: extdata
          name_top: RndCnstOtpCtrlScrmblKey1
          default: 0x957c6a0c9c087e73f96d33de76437066
          randwidth: 128
        }
        {
          name: RndCnstScrmblKey2
          desc: Compile-time scrambling key
          type: otp_ctrl_top_specific_pkg::key_t
          randcount: 128
          randtype: extdata
          name_top: RndCnstOtpCtrlScrmblKey2
          default: 0xe6efaa7743364fabfdadba1867aef4a5
          randwidth: 128
        }
        {
          name: RndCnstScrmblKey3
          desc: Compile-time scrambling key
          type: otp_ctrl_top_specific_pkg::key_t
          randcount: 128
          randtype: extdata
          name_top: RndCnstOtpCtrlScrmblKey3
          default: 0x25d3438c679bc5e1e95b11249ca35dde
          randwidth: 128
        }
        {
          name: RndCnstDigestConst0
          desc: Compile-time digest const
          type: otp_ctrl_top_specific_pkg::digest_const_t
          randcount: 128
          randtype: extdata
          name_top: RndCnstOtpCtrlDigestConst0
          default: 0x32067e1786b83222d00054b2af120ff8
          randwidth: 128
        }
        {
          name: RndCnstDigestConst1
          desc: Compile-time digest const
          type: otp_ctrl_top_specific_pkg::digest_const_t
          randcount: 128
          randtype: extdata
          name_top: RndCnstOtpCtrlDigestConst1
          default: 0x86a0b2454cfa25b23b692148e188c5ca
          randwidth: 128
        }
        {
          name: RndCnstDigestIV0
          desc: Compile-time digest initial vector
          type: otp_ctrl_top_specific_pkg::digest_iv_t
          randcount: 64
          randtype: extdata
          name_top: RndCnstOtpCtrlDigestIV0
          default: 0x49b7c7cd1734b80e
          randwidth: 64
        }
        {
          name: RndCnstDigestIV1
          desc: Compile-time digest initial vector
          type: otp_ctrl_top_specific_pkg::digest_iv_t
          randcount: 64
          randtype: extdata
          name_top: RndCnstOtpCtrlDigestIV1
          default: 0x1ae014cefd7de2cb
          randwidth: 64
        }
        {
          name: RndCnstPartInvDefault
          desc: OTP invalid partition default for buffered partitions
          type: logic [16319:0]
          randcount: 16320
          randtype: extdata
          name_top: RndCnstOtpCtrlPartInvDefault
          default:
          [
            {
              size: 704
              items:
              [
                {
                  size: 320
                  inv_default: 508406651299787982309904825443985373106236637081727939090585644961445206666689630393817246511712
                }
                {
                  size: 384
                  inv_default: 34765581757057702526568169959179506991796799849684129792408382543682161064351438550357191642801906499564079722040959
                }
              ]
            }
            {
              size: 384
              items:
              [
                {
                  size: 64
                  inv_default: 0
                }
                {
                  size: 64
                  inv_default: 16862586926326724172
                }
                {
                  size: 256
                  inv_default: 10206999105613237488305124545664851698610302080045852370886952986780297145526
                }
              ]
            }
            {
              size: 1024
              items:
              [
                {
                  size: 64
                  inv_default: 0
                }
                {
                  size: 64
                  inv_default: 12446391818523284464
                }
                {
                  size: 256
                  inv_default: 63999019030607151289909366880942569362330468042440373196189507388017079630937
                }
                {
                  size: 256
                  inv_default: 81109909720667310531206694470923378649726943238131960830210841988782597012480
                }
                {
                  size: 256
                  inv_default: 58428367318477997995158430436185008200278041856729653820014384131744449381794
                }
                {
                  size: 128
                  inv_default: 257151471457813701810792034009910885873
                }
              ]
            }
            {
              size: 256
              items:
              [
                {
                  size: 64
                  inv_default: 0
                }
                {
                  size: 64
                  inv_default: 10065874593229139721
                }
                {
                  size: 128
                  inv_default: 119626835793529483393158377097849370351
                }
              ]
            }
            {
              size: 384
              items:
              [
                {
                  size: 64
                  inv_default: 0
                }
                {
                  size: 64
                  inv_default: 9673330360152269864
                }
                {
                  size: 128
                  inv_default: 8049454917427216925997827152549284667
                }
                {
                  size: 128
                  inv_default: 191985393975828609903709283012653827085
                }
              ]
            }
            {
              size: 128
              items:
              [
                {
                  size: 64
                  inv_default: 8821601860276922949
                }
                {
                  comment: unallocated space
                  size: 16
                  inv_default: 0
                }
                {
                  size: 8
                  inv_default: 105
                }
                {
                  size: 8
                  inv_default: 105
                }
                {
                  size: 32
                  inv_default: 0
                }
              ]
            }
            {
              size: 576
              items:
              [
                {
                  size: 64
                  inv_default: 16898073465963608763
                }
                {
                  size: 256
                  inv_default: 89960518397345998442210387957448911146016937697982416014732294109643662651482
                }
                {
                  size: 256
                  inv_default: 84636775181865843423447751136542243067225345129144998513113609321933118751675
                }
              ]
            }
            {
              size: 3392
              items:
              [
                {
                  comment: unallocated space
                  size: 32
                  inv_default: 0
                }
                {
                  size: 1120
                  inv_default: 0
                }
                {
                  size: 1120
                  inv_default: 0
                }
                {
                  size: 1120
                  inv_default: 0
                }
              ]
            }
            {
              size: 320
              items:
              [
                {
                  size: 64
                  inv_default: 14656815325044117528
                }
                {
                  size: 256
                  inv_default: 0
                }
              ]
            }
            {
              size: 320
              items:
              [
                {
                  size: 64
                  inv_default: 7544202290022723701
                }
                {
                  size: 256
                  inv_default: 0
                }
              ]
            }
            {
              size: 320
              items:
              [
                {
                  size: 64
                  inv_default: 6297967080745773217
                }
                {
                  size: 256
                  inv_default: 0
                }
              ]
            }
            {
              size: 320
              items:
              [
                {
                  size: 64
                  inv_default: 4275689744169575455
                }
                {
                  size: 256
                  inv_default: 0
                }
              ]
            }
            {
              size: 320
              items:
              [
                {
                  size: 64
                  inv_default: 10448767896760702259
                }
                {
                  size: 256
                  inv_default: 0
                }
              ]
            }
            {
              size: 320
              items:
              [
                {
                  size: 64
                  inv_default: 5650730686695884436
                }
                {
                  size: 256
                  inv_default: 0
                }
              ]
            }
            {
              size: 320
              items:
              [
                {
                  size: 64
                  inv_default: 4036071169128675423
                }
                {
                  size: 256
                  inv_default: 0
                }
              ]
            }
            {
              size: 320
              items:
              [
                {
                  size: 64
                  inv_default: 15819321713790451465
                }
                {
                  size: 256
                  inv_default: 0
                }
              ]
            }
            {
              size: 256
              items:
              [
                {
                  size: 128
                  inv_default: 0
                }
                {
                  size: 128
                  inv_default: 0
                }
              ]
            }
            {
              size: 4800
              items:
              [
                {
                  size: 64
                  inv_default: 4123931682964426286
                }
                {
                  size: 32
                  inv_default: 0
                }
                {
                  size: 32
                  inv_default: 0
                }
                {
                  size: 32
                  inv_default: 0
                }
                {
                  size: 32
                  inv_default: 0
                }
                {
                  size: 32
                  inv_default: 0
                }
                {
                  size: 32
                  inv_default: 0
                }
                {
                  size: 32
                  inv_default: 0
                }
                {
                  size: 32
                  inv_default: 0
                }
                {
                  size: 512
                  inv_default: 0
                }
                {
                  size: 128
                  inv_default: 0
                }
                {
                  size: 128
                  inv_default: 0
                }
                {
                  size: 224
                  inv_default: 0
                }
                {
                  size: 3360
                  inv_default: 0
                }
                {
                  size: 32
                  inv_default: 0
                }
                {
                  size: 32
                  inv_default: 0
                }
                {
                  size: 32
                  inv_default: 0
                }
                {
                  size: 32
                  inv_default: 0
                }
              ]
            }
            {
              size: 1344
              items:
              [
                {
                  size: 64
                  inv_default: 7512587968106004660
                }
                {
                  size: 32
                  inv_default: 0
                }
                {
                  size: 32
                  inv_default: 0
                }
                {
                  size: 32
                  inv_default: 0
                }
                {
                  size: 32
                  inv_default: 0
                }
                {
                  size: 32
                  inv_default: 0
                }
                {
                  size: 32
                  inv_default: 0
                }
                {
                  size: 32
                  inv_default: 0
                }
                {
                  size: 32
                  inv_default: 0
                }
                {
                  size: 32
                  inv_default: 0
                }
                {
                  size: 32
                  inv_default: 0
                }
                {
                  size: 32
                  inv_default: 0
                }
                {
                  size: 32
                  inv_default: 0
                }
                {
                  size: 32
                  inv_default: 0
                }
                {
                  size: 32
                  inv_default: 0
                }
                {
                  size: 32
                  inv_default: 0
                }
                {
                  size: 32
                  inv_default: 0
                }
                {
                  size: 32
                  inv_default: 0
                }
                {
                  size: 32
                  inv_default: 0
                }
                {
                  size: 32
                  inv_default: 0
                }
                {
                  size: 32
                  inv_default: 0
                }
                {
                  size: 32
                  inv_default: 0
                }
                {
                  size: 32
                  inv_default: 0
                }
                {
                  size: 32
                  inv_default: 0
                }
                {
                  size: 32
                  inv_default: 0
                }
                {
                  size: 32
                  inv_default: 0
                }
                {
                  size: 64
                  inv_default: 0
                }
                {
                  size: 32
                  inv_default: 0
                }
                {
                  size: 64
                  inv_default: 0
                }
                {
                  size: 32
                  inv_default: 0
                }
                {
                  size: 32
                  inv_default: 0
                }
                {
                  size: 256
                  inv_default: 0
                }
              ]
            }
            {
              size: 512
              items:
              [
                {
                  size: 64
                  inv_default: 13995797430872360414
                }
                {
                  size: 448
                  inv_default: 0
                }
              ]
            }
          ]
          randwidth: 16320
        }
      ]
      template_type: otp_ctrl
      otp_mmap:
      {
        otp:
        {
          width: 2
          depth: 1024
          size: 2048
          addr_width: 10
          byte_addr_width: 11
        }
        scrambling:
        {
          key_size: 16
          iv_size: 8
          cnst_size: 16
          keys:
          [
            {
              name: Secret0Key
              value: 202807617200252840528729068358060549519
            }
            {
              name: Secret1Key
              value: 198700967116856651033054259582582616166
            }
            {
              name: Secret2Key
              value: 306966855438305588444436821114459452581
            }
            {
              name: Secret3Key
              value: 50278380526644206573154867505977843166
            }
          ]
          digests:
          [
            {
              name: CnstyDigest
              iv_value: 5311933969178343438
              cnst_value: 66495111017948470976885563649124601848
            }
            {
              name: SramDataKey
              iv_value: 1936570719018017483
              cnst_value: 178950934692020233087936965387133437386
            }
          ]
          num_keys: 4
          num_digests: 2
        }
        partitions:
        [
          {
            name: VENDOR_TEST
            variant: Unbuffered
            absorb: false
            secret: false
            sw_digest: true
            hw_digest: false
            write_lock: Digest
            read_lock: CSR
            key_sel: NoKey
            integrity: false
            bkout_type: false
            zeroizable: false
            skip_sw_header: true
            items:
            [
              {
                name: SCRATCH
                size: 56
                isdigest: false
                iszer: false
                ismubi: false
                iskeymgr_creator: false
                iskeymgr_owner: false
                inv_default: 0
                offset: 0
              }
              {
                name: VENDOR_TEST_DIGEST
                size: 8
                offset: 56
                ismubi: false
                isdigest: true
                iszer: false
                inv_default: 13995797430872360414
                iskeymgr_creator: false
                iskeymgr_owner: false
              }
            ]
            desc:
              '''
              Vendor test partition.
              This is reserved for manufacturing smoke checks. The OTP wrapper
              control logic inside prim_otp is allowed to read/write to this
              region. ECC uncorrectable errors seen on the functional prim_otp
              interface will not lead to an alert for this partition.
              Instead, such errors will be reported as correctable ECC errors.
              '''
            iskeymgr_creator: false
            iskeymgr_owner: false
            ignore_read_lock_in_rma: false
            size: 64
            offset: 0
          }
          {
            name: CREATOR_SW_CFG
            variant: Unbuffered
            absorb: false
            secret: false
            sw_digest: true
            hw_digest: false
            write_lock: Digest
            read_lock: CSR
            key_sel: NoKey
            integrity: true
            bkout_type: false
            zeroizable: false
            items:
            [
              {
                name: CREATOR_SW_CFG_OVERRIDES
                size: 32
                isdigest: false
                iszer: false
                ismubi: false
                iskeymgr_creator: false
                iskeymgr_owner: false
                inv_default: 0
                offset: 64
              }
              {
                name: CREATOR_SW_CFG_ROM_EXT_SKU
                size: 4
                isdigest: false
                iszer: false
                ismubi: false
                iskeymgr_creator: false
                iskeymgr_owner: false
                inv_default: 0
                offset: 96
              }
              {
                name: CREATOR_SW_CFG_SIGVERIFY_RSA_MOD_EXP_IBEX_EN
                size: 4
                isdigest: false
                iszer: false
                ismubi: false
                iskeymgr_creator: false
                iskeymgr_owner: false
                inv_default: 0
                offset: 100
              }
              {
                name: CREATOR_SW_CFG_SIGVERIFY_RSA_KEY_EN
                size: 8
                isdigest: false
                iszer: false
                ismubi: false
                iskeymgr_creator: false
                iskeymgr_owner: false
                inv_default: 0
                offset: 104
              }
              {
                name: CREATOR_SW_CFG_SIGVERIFY_SPX_EN
                size: 4
                isdigest: false
                iszer: false
                ismubi: false
                iskeymgr_creator: false
                iskeymgr_owner: false
                inv_default: 0
                offset: 112
              }
              {
                name: CREATOR_SW_CFG_SIGVERIFY_SPX_KEY_EN
                size: 8
                isdigest: false
                iszer: false
                ismubi: false
                iskeymgr_creator: false
                iskeymgr_owner: false
                inv_default: 0
                offset: 116
              }
              {
                name: CREATOR_SW_CFG_RNG_EN
                size: 4
                isdigest: false
                iszer: false
                ismubi: false
                iskeymgr_creator: false
                iskeymgr_owner: false
                inv_default: 0
                offset: 124
              }
              {
                name: CREATOR_SW_CFG_JITTER_EN
                size: 4
                isdigest: false
                iszer: false
                ismubi: false
                iskeymgr_creator: false
                iskeymgr_owner: false
                inv_default: 0
                offset: 128
              }
              {
                name: CREATOR_SW_CFG_RET_RAM_RESET_MASK
                size: 4
                isdigest: false
                iszer: false
                ismubi: false
                iskeymgr_creator: false
                iskeymgr_owner: false
                inv_default: 0
                offset: 132
              }
              {
                name: CREATOR_SW_CFG_MANUF_STATE
                size: 4
                isdigest: false
                iszer: false
                ismubi: false
                iskeymgr_creator: false
                iskeymgr_owner: false
                inv_default: 0
                offset: 136
              }
              {
                name: CREATOR_SW_CFG_ROM_EXEC_EN
                size: 4
                isdigest: false
                iszer: false
                ismubi: false
                iskeymgr_creator: false
                iskeymgr_owner: false
                inv_default: 0
                offset: 140
              }
              {
                name: CREATOR_SW_CFG_CPUCTRL
                size: 4
                isdigest: false
                iszer: false
                ismubi: false
                iskeymgr_creator: false
                iskeymgr_owner: false
                inv_default: 0
                offset: 144
              }
              {
                name: CREATOR_SW_CFG_MIN_SEC_VER_ROM_EXT
                size: 4
                isdigest: false
                iszer: false
                ismubi: false
                iskeymgr_creator: false
                iskeymgr_owner: false
                inv_default: 0
                offset: 148
              }
              {
                name: CREATOR_SW_CFG_MIN_SEC_VER_BL0
                size: 4
                isdigest: false
                iszer: false
                ismubi: false
                iskeymgr_creator: false
                iskeymgr_owner: false
                inv_default: 0
                offset: 152
              }
              {
                name: CREATOR_SW_CFG_DEFAULT_BOOT_DATA_IN_PROD_EN
                size: 4
                isdigest: false
                iszer: false
                ismubi: false
                iskeymgr_creator: false
                iskeymgr_owner: false
                inv_default: 0
                offset: 156
              }
              {
                name: CREATOR_SW_CFG_RMA_SPIN_EN
                size: 4
                isdigest: false
                iszer: false
                ismubi: false
                iskeymgr_creator: false
                iskeymgr_owner: false
                inv_default: 0
                offset: 160
              }
              {
                name: CREATOR_SW_CFG_RMA_SPIN_CYCLES
                size: 4
                isdigest: false
                iszer: false
                ismubi: false
                iskeymgr_creator: false
                iskeymgr_owner: false
                inv_default: 0
                offset: 164
              }
              {
                name: CREATOR_SW_CFG_RNG_REPCNT_THRESHOLDS
                size: 4
                isdigest: false
                iszer: false
                ismubi: false
                iskeymgr_creator: false
                iskeymgr_owner: false
                inv_default: 0
                offset: 168
              }
              {
                name: CREATOR_SW_CFG_RNG_REPCNTS_THRESHOLDS
                size: 4
                isdigest: false
                iszer: false
                ismubi: false
                iskeymgr_creator: false
                iskeymgr_owner: false
                inv_default: 0
                offset: 172
              }
              {
                name: CREATOR_SW_CFG_RNG_ADAPTP_HI_THRESHOLDS
                size: 4
                isdigest: false
                iszer: false
                ismubi: false
                iskeymgr_creator: false
                iskeymgr_owner: false
                inv_default: 0
                offset: 176
              }
              {
                name: CREATOR_SW_CFG_RNG_ADAPTP_LO_THRESHOLDS
                size: 4
                isdigest: false
                iszer: false
                ismubi: false
                iskeymgr_creator: false
                iskeymgr_owner: false
                inv_default: 0
                offset: 180
              }
              {
                name: CREATOR_SW_CFG_RNG_BUCKET_THRESHOLDS
                size: 4
                isdigest: false
                iszer: false
                ismubi: false
                iskeymgr_creator: false
                iskeymgr_owner: false
                inv_default: 0
                offset: 184
              }
              {
                name: CREATOR_SW_CFG_RNG_MARKOV_HI_THRESHOLDS
                size: 4
                isdigest: false
                iszer: false
                ismubi: false
                iskeymgr_creator: false
                iskeymgr_owner: false
                inv_default: 0
                offset: 188
              }
              {
                name: CREATOR_SW_CFG_RNG_MARKOV_LO_THRESHOLDS
                size: 4
                isdigest: false
                iszer: false
                ismubi: false
                iskeymgr_creator: false
                iskeymgr_owner: false
                inv_default: 0
                offset: 192
              }
              {
                name: CREATOR_SW_CFG_RNG_EXTHT_HI_THRESHOLDS
                size: 4
                isdigest: false
                iszer: false
                ismubi: false
                iskeymgr_creator: false
                iskeymgr_owner: false
                inv_default: 0
                offset: 196
              }
              {
                name: CREATOR_SW_CFG_RNG_EXTHT_LO_THRESHOLDS
                size: 4
                isdigest: false
                iszer: false
                ismubi: false
                iskeymgr_creator: false
                iskeymgr_owner: false
                inv_default: 0
                offset: 200
              }
              {
                name: CREATOR_SW_CFG_RNG_BOOT_ALERT_THRESHOLD
                size: 4
                isdigest: false
                iszer: false
                ismubi: false
                iskeymgr_creator: false
                iskeymgr_owner: false
                inv_default: 0
                offset: 204
              }
              {
                name: CREATOR_SW_CFG_RNG_FIPS_ALERT_THRESHOLD
                size: 4
                isdigest: false
                iszer: false
                ismubi: false
                iskeymgr_creator: false
                iskeymgr_owner: false
                inv_default: 0
                offset: 208
              }
              {
                name: CREATOR_SW_CFG_RNG_BOOT_CONFIG_DIGEST
                size: 4
                isdigest: false
                iszer: false
                ismubi: false
                iskeymgr_creator: false
                iskeymgr_owner: false
                inv_default: 0
                offset: 212
              }
              {
                name: CREATOR_SW_CFG_RNG_FIPS_CONFIG_DIGEST
                size: 4
                isdigest: false
                iszer: false
                ismubi: false
                iskeymgr_creator: false
                iskeymgr_owner: false
                inv_default: 0
                offset: 216
              }
              {
                name: CREATOR_SW_CFG_SRAM_KEY_RENEW_AND_INIT_EN
                size: 4
                isdigest: false
                iszer: false
                ismubi: false
                iskeymgr_creator: false
                iskeymgr_owner: false
                inv_default: 0
                offset: 220
              }
              {
                name: CREATOR_SW_CFG_DIGEST
                size: 8
                offset: 224
                ismubi: false
                isdigest: true
                iszer: false
                inv_default: 7512587968106004660
                iskeymgr_creator: false
                iskeymgr_owner: false
              }
            ]
            desc:
              '''
              Software configuration partition.
              This is for device-specific calibration data. For example, clock,
              LDO, RNG.
              '''
            iskeymgr_creator: false
            iskeymgr_owner: false
            ignore_read_lock_in_rma: false
            size: 168
            offset: 64
          }
          {
            name: OWNER_SW_CFG
            variant: Unbuffered
            absorb: false
            secret: false
            sw_digest: true
            hw_digest: false
            write_lock: Digest
            read_lock: CSR
            key_sel: NoKey
            integrity: true
            bkout_type: false
            zeroizable: false
            items:
            [
              {
                name: OWNER_SW_CFG_ROM_ERROR_REPORTING
                size: 4
                isdigest: false
                iszer: false
                ismubi: false
                iskeymgr_creator: false
                iskeymgr_owner: false
                inv_default: 0
                offset: 232
              }
              {
                name: OWNER_SW_CFG_ROM_BOOTSTRAP_DIS
                size: 4
                isdigest: false
                iszer: false
                ismubi: false
                iskeymgr_creator: false
                iskeymgr_owner: false
                inv_default: 0
                offset: 236
              }
              {
                name: OWNER_SW_CFG_ROM_ALERT_CLASS_EN
                size: 4
                isdigest: false
                iszer: false
                ismubi: false
                iskeymgr_creator: false
                iskeymgr_owner: false
                inv_default: 0
                offset: 240
              }
              {
                name: OWNER_SW_CFG_ROM_ALERT_ESCALATION
                size: 4
                isdigest: false
                iszer: false
                ismubi: false
                iskeymgr_creator: false
                iskeymgr_owner: false
                inv_default: 0
                offset: 244
              }
              {
                name: OWNER_SW_CFG_ROM_ALERT_CLASSIFICATION
                size: 420
                isdigest: false
                iszer: false
                ismubi: false
                iskeymgr_creator: false
                iskeymgr_owner: false
                inv_default: 0
                offset: 248
              }
              {
                name: OWNER_SW_CFG_ROM_LOCAL_ALERT_CLASSIFICATION
                size: 28
                isdigest: false
                iszer: false
                ismubi: false
                iskeymgr_creator: false
                iskeymgr_owner: false
                inv_default: 0
                offset: 668
              }
              {
                name: OWNER_SW_CFG_ROM_ALERT_ACCUM_THRESH
                size: 16
                isdigest: false
                iszer: false
                ismubi: false
                iskeymgr_creator: false
                iskeymgr_owner: false
                inv_default: 0
                offset: 696
              }
              {
                name: OWNER_SW_CFG_ROM_ALERT_TIMEOUT_CYCLES
                size: 16
                isdigest: false
                iszer: false
                ismubi: false
                iskeymgr_creator: false
                iskeymgr_owner: false
                inv_default: 0
                offset: 712
              }
              {
                name: OWNER_SW_CFG_ROM_ALERT_PHASE_CYCLES
                size: 64
                isdigest: false
                iszer: false
                ismubi: false
                iskeymgr_creator: false
                iskeymgr_owner: false
                inv_default: 0
                offset: 728
              }
              {
                name: OWNER_SW_CFG_ROM_ALERT_DIGEST_PROD
                size: 4
                isdigest: false
                iszer: false
                ismubi: false
                iskeymgr_creator: false
                iskeymgr_owner: false
                inv_default: 0
                offset: 792
              }
              {
                name: OWNER_SW_CFG_ROM_ALERT_DIGEST_PROD_END
                size: 4
                isdigest: false
                iszer: false
                ismubi: false
                iskeymgr_creator: false
                iskeymgr_owner: false
                inv_default: 0
                offset: 796
              }
              {
                name: OWNER_SW_CFG_ROM_ALERT_DIGEST_DEV
                size: 4
                isdigest: false
                iszer: false
                ismubi: false
                iskeymgr_creator: false
                iskeymgr_owner: false
                inv_default: 0
                offset: 800
              }
              {
                name: OWNER_SW_CFG_ROM_ALERT_DIGEST_RMA
                size: 4
                isdigest: false
                iszer: false
                ismubi: false
                iskeymgr_creator: false
                iskeymgr_owner: false
                inv_default: 0
                offset: 804
              }
              {
                name: OWNER_SW_CFG_ROM_WATCHDOG_BITE_THRESHOLD_CYCLES
                size: 4
                isdigest: false
                iszer: false
                ismubi: false
                iskeymgr_creator: false
                iskeymgr_owner: false
                inv_default: 0
                offset: 808
              }
              {
                name: OWNER_SW_CFG_ROM_KEYMGR_ROM_EXT_MEAS_EN
                size: 4
                isdigest: false
                iszer: false
                ismubi: false
                iskeymgr_creator: false
                iskeymgr_owner: false
                inv_default: 0
                offset: 812
              }
              {
                name: OWNER_SW_CFG_MANUF_STATE
                size: 4
                isdigest: false
                iszer: false
                ismubi: false
                iskeymgr_creator: false
                iskeymgr_owner: false
                inv_default: 0
                offset: 816
              }
              {
                name: OWNER_SW_CFG_ROM_RSTMGR_INFO_EN
                size: 4
                isdigest: false
                iszer: false
                ismubi: false
                iskeymgr_creator: false
                iskeymgr_owner: false
                inv_default: 0
                offset: 820
              }
              {
                name: OWNER_SW_CFG_DIGEST
                size: 8
                offset: 824
                ismubi: false
                isdigest: true
                iszer: false
                inv_default: 4123931682964426286
                iskeymgr_creator: false
                iskeymgr_owner: false
              }
            ]
            desc:
              '''
              Software configuration partition.
              This contains data that changes software behavior in the ROM, for
              example enabling defensive features in ROM or selecting failure
              modes if verification fails.
              '''
            iskeymgr_creator: false
            iskeymgr_owner: false
            ignore_read_lock_in_rma: false
            size: 600
            offset: 232
          }
          {
            name: AUTH_SLOT_STATE
            variant: Unbuffered
            absorb: false
            secret: false
            sw_digest: false
            hw_digest: false
            write_lock: None
            read_lock: CSR
            key_sel: NoKey
            integrity: true
            bkout_type: false
            zeroizable: false
            items:
            [
              {
                name: AUTH_SLOT_STATE_ROT_FIRMWARE
                size: 16
                desc:
                  '''
                  RoT Firmware Auth Slot State
                  SLOT_ST_RAW:       slot not yet claimed (factory default)
                  SLOT_ST_LOCKED0:   first slot claimed
                  SLOT_ST_RELEASED0: first slot released (assets have been cleared, ready to xfer)
                  SLOT_ST_LOCKED1:   second slot claimed
                  SLOT_ST_RELEASED1: second slot released (assets have been cleared, ready to xfer)
                  SLOT_ST_LOCKED2:   third slot claimed
                  SLOT_ST_RELEASED2: third slot released (assets have been cleared, ready to xfer)
                  SLOT_ST_LOCKED3:   fourth slot claimed
                  SLOT_ST_SCRAPPED:  scrap state - terminal
                  '''
                isdigest: false
                iszer: false
                ismubi: false
                iskeymgr_creator: false
                iskeymgr_owner: false
                inv_default: 0
                offset: 832
              }
              {
                name: AUTH_SLOT_STATE_SOC_FIRMWARE
                size: 16
                desc:
                  '''
                  SoC Firmware Key Slot State
                  SLOT_ST_RAW:       slot not yet claimed (factory default)
                  SLOT_ST_LOCKED0:   first slot claimed
                  SLOT_ST_RELEASED0: first slot released (assets have been cleared, ready to xfer)
                  SLOT_ST_LOCKED1:   second slot claimed
                  SLOT_ST_RELEASED1: second slot released (assets have been cleared, ready to xfer)
                  SLOT_ST_LOCKED2:   third slot claimed
                  SLOT_ST_RELEASED2: third slot released (assets have been cleared, ready to xfer)
                  SLOT_ST_LOCKED3:   fourth slot claimed
                  SLOT_ST_SCRAPPED:  scrap state - terminal
                  '''
                isdigest: false
                iszer: false
                ismubi: false
                iskeymgr_creator: false
                iskeymgr_owner: false
                inv_default: 0
                offset: 848
              }
            ]
            desc:
              '''
              SW managed authentication slot states partition.

              Multibit enable value for the tracking the authentication slot states.
              Note that the states can be written multiple times in a device lifetime.
              The values to be written are engineered in the same way as the LC_CTRL
              state encoding words so that the ECC encoding remains valid even after
              updating the values.

              The constants can be found in the lc_ctrl_state_pkg.sv package.

              The programming order has to adhere to:

              SLOT_ST_RAW (factory all-zero state) ->
              SLOT_ST_LOCKED0 ->
              SLOT_ST_RELEASED0 ->
              ...
              SLOT_ST_SCRAPPED

              Note that if there are less than 4 slots available the higher slot states
              become logically equivalent to SLOT_ST_SCRAPPED (firmware has to handle
              this correctly).
              '''
            iskeymgr_creator: false
            iskeymgr_owner: false
            ignore_read_lock_in_rma: false
            size: 32
            offset: 832
          }
          {
            name: ROT_FIRMWARE_AUTH_SLOT0
            variant: Unbuffered
            absorb: false
            secret: false
            sw_digest: true
            hw_digest: false
            write_lock: Digest
            read_lock: CSR
            key_sel: NoKey
            integrity: true
            bkout_type: false
            zeroizable: false
            items:
            [
              {
                name: ROT_FIRMWARE_AUTH_SLOT0_HASH
                size: 32
                desc: Hash of public key for RoT firmware (slot 0)
                isdigest: false
                iszer: false
                ismubi: false
                iskeymgr_creator: false
                iskeymgr_owner: false
                inv_default: 0
                offset: 864
              }
              {
                name: ROT_FIRMWARE_AUTH_SLOT0_DIGEST
                size: 8
                offset: 896
                ismubi: false
                isdigest: true
                iszer: false
                inv_default: 15819321713790451465
                iskeymgr_creator: false
                iskeymgr_owner: false
              }
            ]
            desc: Software managed RoT firmware authentication slot
            iskeymgr_creator: false
            iskeymgr_owner: false
            ignore_read_lock_in_rma: false
            size: 40
            offset: 864
          }
          {
            name: ROT_FIRMWARE_AUTH_SLOT1
            variant: Unbuffered
            absorb: false
            secret: false
            sw_digest: true
            hw_digest: false
            write_lock: Digest
            read_lock: CSR
            key_sel: NoKey
            integrity: true
            bkout_type: false
            zeroizable: false
            items:
            [
              {
                name: ROT_FIRMWARE_AUTH_SLOT1_HASH
                size: 32
                desc: Hash of public key for RoT firmware (slot 1)
                isdigest: false
                iszer: false
                ismubi: false
                iskeymgr_creator: false
                iskeymgr_owner: false
                inv_default: 0
                offset: 904
              }
              {
                name: ROT_FIRMWARE_AUTH_SLOT1_DIGEST
                size: 8
                offset: 936
                ismubi: false
                isdigest: true
                iszer: false
                inv_default: 4036071169128675423
                iskeymgr_creator: false
                iskeymgr_owner: false
              }
            ]
            desc: Software managed RoT firmware authentication slot
            iskeymgr_creator: false
            iskeymgr_owner: false
            ignore_read_lock_in_rma: false
            size: 40
            offset: 904
          }
          {
            name: ROT_FIRMWARE_AUTH_SLOT2
            variant: Unbuffered
            absorb: false
            secret: false
            sw_digest: true
            hw_digest: false
            write_lock: Digest
            read_lock: CSR
            key_sel: NoKey
            integrity: true
            bkout_type: false
            zeroizable: false
            items:
            [
              {
                name: ROT_FIRMWARE_AUTH_SLOT2_HASH
                size: 32
                desc: Hash of public key for RoT firmware (slot 2)
                isdigest: false
                iszer: false
                ismubi: false
                iskeymgr_creator: false
                iskeymgr_owner: false
                inv_default: 0
                offset: 944
              }
              {
                name: ROT_FIRMWARE_AUTH_SLOT2_DIGEST
                size: 8
                offset: 976
                ismubi: false
                isdigest: true
                iszer: false
                inv_default: 5650730686695884436
                iskeymgr_creator: false
                iskeymgr_owner: false
              }
            ]
            desc: Software managed RoT firmware authentication slot
            iskeymgr_creator: false
            iskeymgr_owner: false
            ignore_read_lock_in_rma: false
            size: 40
            offset: 944
          }
          {
            name: ROT_FIRMWARE_AUTH_SLOT3
            variant: Unbuffered
            absorb: false
            secret: false
            sw_digest: true
            hw_digest: false
            write_lock: Digest
            read_lock: CSR
            key_sel: NoKey
            integrity: true
            bkout_type: false
            zeroizable: false
            items:
            [
              {
                name: ROT_FIRMWARE_AUTH_SLOT3_HASH
                size: 32
                desc: Hash of public key for RoT firmware (slot 3)
                isdigest: false
                iszer: false
                ismubi: false
                iskeymgr_creator: false
                iskeymgr_owner: false
                inv_default: 0
                offset: 984
              }
              {
                name: ROT_FIRMWARE_AUTH_SLOT3_DIGEST
                size: 8
                offset: 1016
                ismubi: false
                isdigest: true
                iszer: false
                inv_default: 10448767896760702259
                iskeymgr_creator: false
                iskeymgr_owner: false
              }
            ]
            desc: Software managed RoT firmware authentication slot
            iskeymgr_creator: false
            iskeymgr_owner: false
            ignore_read_lock_in_rma: false
            size: 40
            offset: 984
          }
          {
            name: SOC_FIRMWARE_AUTH_SLOT0
            variant: Unbuffered
            absorb: false
            secret: false
            sw_digest: true
            hw_digest: false
            write_lock: Digest
            read_lock: CSR
            key_sel: NoKey
            integrity: true
            bkout_type: false
            zeroizable: false
            items:
            [
              {
                name: SOC_FIRMWARE_AUTH_SLOT0_HASH
                size: 32
                desc: Hash of public key for SoC firmware (slot 0)
                isdigest: false
                iszer: false
                ismubi: false
                iskeymgr_creator: false
                iskeymgr_owner: false
                inv_default: 0
                offset: 1024
              }
              {
                name: SOC_FIRMWARE_AUTH_SLOT0_DIGEST
                size: 8
                offset: 1056
                ismubi: false
                isdigest: true
                iszer: false
                inv_default: 4275689744169575455
                iskeymgr_creator: false
                iskeymgr_owner: false
              }
            ]
            desc: Software managed SoC firmware authentication slot
            iskeymgr_creator: false
            iskeymgr_owner: false
            ignore_read_lock_in_rma: false
            size: 40
            offset: 1024
          }
          {
            name: SOC_FIRMWARE_AUTH_SLOT1
            variant: Unbuffered
            absorb: false
            secret: false
            sw_digest: true
            hw_digest: false
            write_lock: Digest
            read_lock: CSR
            key_sel: NoKey
            integrity: true
            bkout_type: false
            zeroizable: false
            items:
            [
              {
                name: SOC_FIRMWARE_AUTH_SLOT1_HASH
                size: 32
                desc: Hash of public key for SoC firmware (slot 1)
                isdigest: false
                iszer: false
                ismubi: false
                iskeymgr_creator: false
                iskeymgr_owner: false
                inv_default: 0
                offset: 1064
              }
              {
                name: SOC_FIRMWARE_AUTH_SLOT1_DIGEST
                size: 8
                offset: 1096
                ismubi: false
                isdigest: true
                iszer: false
                inv_default: 6297967080745773217
                iskeymgr_creator: false
                iskeymgr_owner: false
              }
            ]
            desc: Software managed SoC firmware authentication slot
            iskeymgr_creator: false
            iskeymgr_owner: false
            ignore_read_lock_in_rma: false
            size: 40
            offset: 1064
          }
          {
            name: SOC_FIRMWARE_AUTH_SLOT2
            variant: Unbuffered
            absorb: false
            secret: false
            sw_digest: true
            hw_digest: false
            write_lock: Digest
            read_lock: CSR
            key_sel: NoKey
            integrity: true
            bkout_type: false
            zeroizable: false
            items:
            [
              {
                name: SOC_FIRMWARE_AUTH_SLOT2_HASH
                size: 32
                desc: Hash of public key for SoC firmware (slot 2)
                isdigest: false
                iszer: false
                ismubi: false
                iskeymgr_creator: false
                iskeymgr_owner: false
                inv_default: 0
                offset: 1104
              }
              {
                name: SOC_FIRMWARE_AUTH_SLOT2_DIGEST
                size: 8
                offset: 1136
                ismubi: false
                isdigest: true
                iszer: false
                inv_default: 7544202290022723701
                iskeymgr_creator: false
                iskeymgr_owner: false
              }
            ]
            desc: Software managed SoC firmware authentication slot
            iskeymgr_creator: false
            iskeymgr_owner: false
            ignore_read_lock_in_rma: false
            size: 40
            offset: 1104
          }
          {
            name: SOC_FIRMWARE_AUTH_SLOT3
            variant: Unbuffered
            absorb: false
            secret: false
            sw_digest: true
            hw_digest: false
            write_lock: Digest
            read_lock: CSR
            key_sel: NoKey
            integrity: true
            bkout_type: false
            zeroizable: false
            items:
            [
              {
                name: SOC_FIRMWARE_AUTH_SLOT3_HASH
                size: 32
                desc: Hash of public key for SoC firmware (slot 3)
                isdigest: false
                iszer: false
                ismubi: false
                iskeymgr_creator: false
                iskeymgr_owner: false
                inv_default: 0
                offset: 1144
              }
              {
                name: SOC_FIRMWARE_AUTH_SLOT3_DIGEST
                size: 8
                offset: 1176
                ismubi: false
                isdigest: true
                iszer: false
                inv_default: 14656815325044117528
                iskeymgr_creator: false
                iskeymgr_owner: false
              }
            ]
            desc: Software managed SoC firmware authentication slot
            iskeymgr_creator: false
            iskeymgr_owner: false
            ignore_read_lock_in_rma: false
            size: 40
            offset: 1144
          }
          {
            name: EXT_NVM
            variant: Unbuffered
            absorb: false
            secret: false
            sw_digest: false
            hw_digest: false
            write_lock: None
            read_lock: CSR
            key_sel: NoKey
            integrity: false
            bkout_type: false
            zeroizable: false
            items:
            [
              {
                name: EXT_ROM_FRESHNESS_CNT
                size: 140
                desc:
                  '''
                  ROM_EXT rollback protection Strike Counter
                  1 bit (double bit allocated for redundancy - i.e. 2 physical bits for every logical bit) per half week
                  assuming 5 year product lifecycle, allocating 1120 bits of freshness protection.
                  Implemented as thermometer encoding. Redundant bit programming & logical OR-ing managed by
                  software. Cannot be ECC protected since different bits in a fuse row are programmed at different times.
                  '''
                isdigest: false
                iszer: false
                ismubi: false
                iskeymgr_creator: false
                iskeymgr_owner: false
                inv_default: 0
                offset: 1184
              }
              {
                name: EXT_SOC_FIRMWARE_FRESHNESS_CNT
                size: 140
                desc:
                  '''
                  SoC firmware rollback protection Strike Counter
                  1 bit (double bit allocated for redundancy - i.e. 2 physical bits for every logical bit) per half week
                  assuming 5 year product lifecycle, allocating 1120 bits of freshness protection.
                  Implemented as thermometer encoding. Redundant bit programming & logical OR-ing managed by
                  software. Cannot be ECC protected since different bits in a fuse row are programmed at different times.
                  '''
                isdigest: false
                iszer: false
                ismubi: false
                iskeymgr_creator: false
                iskeymgr_owner: false
                inv_default: 0
                offset: 1324
              }
              {
                name: EXT_SOC_RECOVERY_FIRMWARE_FRESHNESS_CNT
                size: 140
                desc:
                  '''
                  SoC recovery firmware rollback protection Strike Counter
                  1 bit (double bit allocated for redundancy - i.e. 2 physical bits for every logical bit) per half week
                  assuming 5 year product lifecycle, allocating 1120 bits of freshness protection.
                  Implemented as thermometer encoding. Redundant bit programming & logical OR-ing managed by
                  software. Cannot be ECC protected since different bits in a fuse row are programmed at different times.
                  '''
                isdigest: false
                iszer: false
                ismubi: false
                iskeymgr_creator: false
                iskeymgr_owner: false
                inv_default: 0
                offset: 1464
              }
            ]
            desc: SW managed Anti-replay protection Strike Counters partition.
            iskeymgr_creator: false
            iskeymgr_owner: false
            ignore_read_lock_in_rma: false
            size: 424
            offset: 1184
          }
          {
            name: HW_CFG0
            variant: Buffered
            secret: false
            sw_digest: false
            hw_digest: true
            write_lock: Digest
            read_lock: None
            key_sel: NoKey
            integrity: true
            bkout_type: true
            zeroizable: false
            skip_sw_header: true
            items:
            [
              {
                name: DEVICE_ID
                size: 32
                inv_default: 84636775181865843423447751136542243067225345129144998513113609321933118751675
                isdigest: false
                iszer: false
                ismubi: false
                iskeymgr_creator: false
                iskeymgr_owner: false
                offset: 1608
              }
              {
                name: MANUF_STATE
                size: 32
                inv_default: 89960518397345998442210387957448911146016937697982416014732294109643662651482
                isdigest: false
                iszer: false
                ismubi: false
                iskeymgr_creator: false
                iskeymgr_owner: false
                offset: 1640
              }
              {
                name: HW_CFG0_DIGEST
                size: 8
                offset: 1672
                ismubi: false
                isdigest: true
                iszer: false
                inv_default: 16898073465963608763
                iskeymgr_creator: false
                iskeymgr_owner: false
              }
            ]
            desc:
              '''
              Hardware configuration 0 partition.
              This contains
              - DEVICE_ID: Unique device identifier.
              - MANUF_STATE: Vector for capturing the manufacturing status.
              '''
            absorb: false
            iskeymgr_creator: false
            iskeymgr_owner: false
            ignore_read_lock_in_rma: false
            size: 72
            offset: 1608
          }
          {
            name: HW_CFG1
            variant: Buffered
            secret: false
            sw_digest: false
            hw_digest: true
            write_lock: Digest
            read_lock: None
            key_sel: NoKey
            integrity: true
            bkout_type: true
            zeroizable: false
            skip_sw_header: true
            items:
            [
              {
                name: SEC_BOOT_DBG
                size: 4
                inv_default: 0
                desc:
                  '''
                  Multibit enable value for Secure Boot.
                  Encoding TBD
                  '''
                isdigest: false
                iszer: false
                ismubi: false
                iskeymgr_creator: false
                iskeymgr_owner: false
                offset: 1680
              }
              {
                name: EN_CSRNG_SW_APP_READ
                size: 1
                ismubi: true
                inv_default: 105
                desc:
                  '''
                  Enablement of CSRNG software application interface. A
                  kMultiBitBool8True value enables, while all other values
                  disable. Enablement is required to extract output from
                  CSRNG via software.
                  '''
                isdigest: false
                iszer: false
                iskeymgr_creator: false
                iskeymgr_owner: false
                offset: 1684
              }
              {
                name: EN_SRAM_IFETCH
                size: 1
                ismubi: true
                inv_default: 105
                isdigest: false
                iszer: false
                iskeymgr_creator: false
                iskeymgr_owner: false
                offset: 1685
              }
              {
                name: HW_CFG1_DIGEST
                size: 8
                offset: 1688
                ismubi: false
                isdigest: true
                iszer: false
                inv_default: 8821601860276922949
                iskeymgr_creator: false
                iskeymgr_owner: false
              }
            ]
            desc:
              '''
              Hardware configuration 1 partition.
              This contains
              EN_SRAM_IFETCH: Enable / disable execute from SRAM CSR switch.
              SOC_DBG_STATE: Multibit enable value for the SOC debug authorization.
              Note SOC_DBG_STATE will be written twice in a device lifetime. The
              values to be written are engineered in the same way as the LC_CTRL
              state encoding words: the ECC encoding remains valid even after
              writing the second value on top of the first.

              The constants can be found in the lc_ctrl_state_pkg.sv package.

              The programming order has to adhere to:

              SOC_DBG_RAW -> SOC_DBG_PRE_PROD -> SOC_DBG_PROD.
              '''
            absorb: false
            iskeymgr_creator: false
            iskeymgr_owner: false
            ignore_read_lock_in_rma: false
            size: 16
            offset: 1680
          }
          {
            name: SECRET0
            variant: Buffered
            secret: true
            sw_digest: false
            hw_digest: true
            write_lock: Digest
            read_lock: Digest
            ignore_read_lock_in_rma: true
            key_sel: Secret0Key
            integrity: true
            bkout_type: false
            zeroizable: true
            skip_sw_header: true
            items:
            [
              {
                name: TEST_UNLOCK_TOKEN
                inv_default: 191985393975828609903709283012653827085
                size: 16
                isdigest: false
                iszer: false
                ismubi: false
                iskeymgr_creator: false
                iskeymgr_owner: false
                offset: 1696
              }
              {
                name: TEST_EXIT_TOKEN
                inv_default: 8049454917427216925997827152549284667
                size: 16
                isdigest: false
                iszer: false
                ismubi: false
                iskeymgr_creator: false
                iskeymgr_owner: false
                offset: 1712
              }
              {
                name: SECRET0_DIGEST
                size: 8
                offset: 1728
                ismubi: false
                isdigest: true
                iszer: false
                inv_default: 9673330360152269864
                iskeymgr_creator: false
                iskeymgr_owner: false
              }
              {
                name: SECRET0_ZER
                size: 8
                offset: 1736
                ismubi: false
                isdigest: false
                iszer: true
                inv_default: 0
                iskeymgr_creator: false
                iskeymgr_owner: false
              }
            ]
            desc:
              '''
              Secret partition 0.
              This contains TEST lifecycle unlock tokens.
              '''
            absorb: false
            iskeymgr_creator: false
            iskeymgr_owner: false
            size: 48
            offset: 1696
          }
          {
            name: SECRET1
            variant: Buffered
            secret: true
            sw_digest: false
            hw_digest: true
            write_lock: Digest
            read_lock: Digest
            ignore_read_lock_in_rma: true
            key_sel: Secret1Key
            integrity: true
            bkout_type: false
            zeroizable: true
            skip_sw_header: true
            items:
            [
              {
                name: SRAM_DATA_KEY_SEED
                inv_default: 119626835793529483393158377097849370351
                size: 16
                isdigest: false
                iszer: false
                ismubi: false
                iskeymgr_creator: false
                iskeymgr_owner: false
                offset: 1744
              }
              {
                name: SECRET1_DIGEST
                size: 8
                offset: 1760
                ismubi: false
                isdigest: true
                iszer: false
                inv_default: 10065874593229139721
                iskeymgr_creator: false
                iskeymgr_owner: false
              }
              {
                name: SECRET1_ZER
                size: 8
                offset: 1768
                ismubi: false
                isdigest: false
                iszer: true
                inv_default: 0
                iskeymgr_creator: false
                iskeymgr_owner: false
              }
            ]
            desc:
              '''
              Secret partition 1.
              This contains the SRAM scrambling key seed.
              '''
            absorb: false
            iskeymgr_creator: false
            iskeymgr_owner: false
            size: 32
            offset: 1744
          }
          {
            name: SECRET2
            variant: Buffered
            secret: true
            sw_digest: false
            hw_digest: true
            write_lock: Digest
            read_lock: Digest
            ignore_read_lock_in_rma: true
            key_sel: Secret2Key
            integrity: true
            bkout_type: false
            zeroizable: true
            skip_sw_header: true
            items:
            [
              {
                name: RMA_TOKEN
                inv_default: 257151471457813701810792034009910885873
                size: 16
                isdigest: false
                iszer: false
                ismubi: false
                iskeymgr_creator: false
                iskeymgr_owner: false
                offset: 1776
              }
              {
                name: CREATOR_ROOT_KEY_SHARE0
                inv_default: 58428367318477997995158430436185008200278041856729653820014384131744449381794
                size: 32
                iskeymgr_creator: true
                isdigest: false
                iszer: false
                ismubi: false
                iskeymgr_owner: false
                offset: 1792
              }
              {
                name: CREATOR_ROOT_KEY_SHARE1
                inv_default: 81109909720667310531206694470923378649726943238131960830210841988782597012480
                size: 32
                iskeymgr_creator: true
                isdigest: false
                iszer: false
                ismubi: false
                iskeymgr_owner: false
                offset: 1824
              }
              {
                name: CREATOR_SEED
                inv_default: 63999019030607151289909366880942569362330468042440373196189507388017079630937
                size: 32
                iskeymgr_creator: true
                isdigest: false
                iszer: false
                ismubi: false
                iskeymgr_owner: false
                offset: 1856
              }
              {
                name: SECRET2_DIGEST
                size: 8
                offset: 1888
                ismubi: false
                isdigest: true
                iszer: false
                inv_default: 12446391818523284464
                iskeymgr_creator: false
                iskeymgr_owner: false
              }
              {
                name: SECRET2_ZER
                size: 8
                offset: 1896
                ismubi: false
                isdigest: false
                iszer: true
                inv_default: 0
                iskeymgr_creator: false
                iskeymgr_owner: false
              }
            ]
            desc:
              '''
              Secret partition 2.
              This contains RMA unlock token, creator root key, and creator seed.
              '''
            absorb: false
            iskeymgr_creator: true
            iskeymgr_owner: false
            size: 128
            offset: 1776
          }
          {
            name: SECRET3
            variant: Buffered
            secret: true
            sw_digest: false
            hw_digest: true
            write_lock: Digest
            read_lock: Digest
            key_sel: Secret3Key
            integrity: true
            bkout_type: false
            zeroizable: true
            skip_sw_header: true
            items:
            [
              {
                name: OWNER_SEED
                inv_default: 10206999105613237488305124545664851698610302080045852370886952986780297145526
                size: 32
                iskeymgr_owner: true
                isdigest: false
                iszer: false
                ismubi: false
                iskeymgr_creator: false
                offset: 1904
              }
              {
                name: SECRET3_DIGEST
                size: 8
                offset: 1936
                ismubi: false
                isdigest: true
                iszer: false
                inv_default: 16862586926326724172
                iskeymgr_creator: false
                iskeymgr_owner: false
              }
              {
                name: SECRET3_ZER
                size: 8
                offset: 1944
                ismubi: false
                isdigest: false
                iszer: true
                inv_default: 0
                iskeymgr_creator: false
                iskeymgr_owner: false
              }
            ]
            desc:
              '''
              Secret partition 3.
              This contains the owner seed.
              '''
            absorb: false
            iskeymgr_creator: false
            iskeymgr_owner: true
            ignore_read_lock_in_rma: false
            size: 48
            offset: 1904
          }
          {
            name: LIFE_CYCLE
            variant: LifeCycle
            secret: false
            sw_digest: false
            hw_digest: false
            write_lock: None
            read_lock: None
            key_sel: NoKey
            integrity: true
            bkout_type: false
            skip_sw_header: true
            items:
            [
              {
                name: LC_TRANSITION_CNT
                inv_default: 34765581757057702526568169959179506991796799849684129792408382543682161064351438550357191642801906499564079722040959
                size: 48
                isdigest: false
                iszer: false
                ismubi: false
                iskeymgr_creator: false
                iskeymgr_owner: false
                offset: 1952
              }
              {
                name: LC_STATE
                inv_default: 508406651299787982309904825443985373106236637081727939090585644961445206666689630393817246511712
                size: 40
                isdigest: false
                iszer: false
                ismubi: false
                iskeymgr_creator: false
                iskeymgr_owner: false
                offset: 2000
              }
            ]
            desc:
              '''
              Lifecycle partition.
              This contains lifecycle transition count and state. This partition
              cannot be locked since the life cycle state needs to advance to RMA
              in-field. Note that while this partition is not marked secret, it
              is not readable nor writeable via the DAI. Only the LC controller
              can access this partition, and even via the LC controller it is not
              possible to read the raw manufacturing life cycle state in encoded
              form, since that encoding is considered a netlist secret. The LC
              controller only exposes a decoded version of this state.
              '''
            absorb: false
            iskeymgr_creator: false
            iskeymgr_owner: false
            zeroizable: false
            ignore_read_lock_in_rma: false
            size: 88
            offset: 1952
          }
        ]
      }
    }
    {
      name: lc_ctrl
      type: lc_ctrl
      base_addrs:
      {
        regs:
        {
          hart: 0x40030000
        }
        dmi:
        {
          soc_dbg: 0x3000
        }
      }
      memory: {}
      param_list:
      [
        {
          name: RndCnstLcKeymgrDivInvalid
          desc: Diversification value used for all invalid life cycle states.
          type: lc_ctrl_pkg::lc_keymgr_div_t
          randcount: 128
          randtype: data
          name_top: RndCnstLcCtrlLcKeymgrDivInvalid
          default: 0xfc6d05b942c3e576506cf775086cfe70
          randwidth: 128
        }
        {
          name: RndCnstLcKeymgrDivTestUnlocked
          desc: Diversification value used for the TEST_UNLOCKED* life cycle states.
          type: lc_ctrl_pkg::lc_keymgr_div_t
          randcount: 128
          randtype: data
          name_top: RndCnstLcCtrlLcKeymgrDivTestUnlocked
          default: 0xcb4daf4db8f49f21fd6d59e9d849e862
          randwidth: 128
        }
        {
          name: RndCnstLcKeymgrDivDev
          desc: Diversification value used for the DEV life cycle state.
          type: lc_ctrl_pkg::lc_keymgr_div_t
          randcount: 128
          randtype: data
          name_top: RndCnstLcCtrlLcKeymgrDivDev
          default: 0x5b39dd880d75e2427437a2385fc12be3
          randwidth: 128
        }
        {
          name: RndCnstLcKeymgrDivProduction
          desc: Diversification value used for the PROD/PROD_END life cycle states.
          type: lc_ctrl_pkg::lc_keymgr_div_t
          randcount: 128
          randtype: data
          name_top: RndCnstLcCtrlLcKeymgrDivProduction
          default: 0xc5333d77aee81229ad96c8c596eda91a
          randwidth: 128
        }
        {
          name: RndCnstLcKeymgrDivRma
          desc: Diversification value used for the RMA life cycle state.
          type: lc_ctrl_pkg::lc_keymgr_div_t
          randcount: 128
          randtype: data
          name_top: RndCnstLcCtrlLcKeymgrDivRma
          default: 0x2485301a48907c59639294c33b5f713f
          randwidth: 128
        }
        {
          name: RndCnstInvalidTokens
          desc: Compile-time random bits used for invalid tokens in the token mux
          type: lc_ctrl_pkg::lc_token_mux_t
          randcount: 1024
          randtype: data
          name_top: RndCnstLcCtrlInvalidTokens
          default: 0xdefa9c76ca907a2610a62d08f074ce9d1b8c9a8d23f56fd2c1a29eea9c28b881457ddd29cda6748f9052c4e410a914d67ca904568db527ebd7543a4689bd951b183cb8bf216f284e65e1fde71df816c143c2575bd40de3e98a45ce844ae951afc889275ace54104d8883c173c10dffac297ae0f92f3724ba10b3a0a91b5288a3
          randwidth: 1024
        }
      ]
    }
    {
      name: aes
      type: aes
      base_addrs:
      {
        null:
        {
          hart: 0x40100000
        }
      }
      memory: {}
      param_list:
      [
        {
          name: RndCnstClearingLfsrSeed
          desc: Default seed of the PRNG used for register clearing.
          type: aes_pkg::clearing_lfsr_seed_t
          randcount: 64
          randtype: data
          name_top: RndCnstAesClearingLfsrSeed
          default: 0xbdcbdfd488fa3778
          randwidth: 64
        }
        {
          name: RndCnstClearingLfsrPerm
          desc: Permutation applied to the LFSR of the PRNG used for clearing.
          type: aes_pkg::clearing_lfsr_perm_t
          randcount: 64
          randtype: perm
          name_top: RndCnstAesClearingLfsrPerm
          default: 0xae0773a05a862e1ef00844d95e27885bfb6ebcab0c739e070f57c0dce372da66fc6a33c9529915d01498f654719d0fba
          randwidth: 384
        }
        {
          name: RndCnstClearingSharePerm
          desc: Permutation applied to the clearing PRNG output for clearing the second share of registers.
          type: aes_pkg::clearing_lfsr_perm_t
          randcount: 64
          randtype: perm
          name_top: RndCnstAesClearingSharePerm
          default: 0xb3174c52d9dcdcb062011bfe68683a60f58dac78fda790f6bbc8526c22683a47de40a5e6cd5e05fd3c2a132235ef4959
          randwidth: 384
        }
        {
          name: RndCnstMaskingLfsrSeed
          desc: Default seed of the PRNG used for masking.
          type: aes_pkg::masking_lfsr_seed_t
          randcount: 288
          randtype: data
          name_top: RndCnstAesMaskingLfsrSeed
          default: 0x38df9077469a0cab69ac24eebab82afe4759cfc663225c12d7753aa2ee916025df0be5c2
          randwidth: 288
        }
        {
          name: RndCnstMaskingLfsrPerm
          desc: Permutation applied to the output of the PRNG used for masking.
          type: aes_pkg::masking_lfsr_perm_t
          randcount: 160
          randtype: perm
          name_top: RndCnstAesMaskingLfsrPerm
          default: 0x853e94418c8150272a66306c3c4591876e001d75575c0b538e4d8b7e281f2640383a9033481806955d9a864f1e7b46447d61761909132e65343236835b1403499f100c235f520a3d2999792b223b05982c1a705e5408165889119e120f3f2577151b8073512455828a60846f964772972f7a7174014268177f62028d434e0792784c6356397c9b93880d2d046a315a1c676b6d5921644a37359c690e9d204b8f
          randwidth: 1280
        }
      ]
    }
    {
      name: kmac
      type: kmac
      base_addrs:
      {
        null:
        {
          hart: 0x40120000
        }
      }
      memory: {}
      param_list:
      [
        {
          name: RndCnstLfsrSeed
          desc: Compile-time random data for PRNG default seed
          type: kmac_pkg::lfsr_seed_t
          randcount: 288
          randtype: data
          name_top: RndCnstKmacLfsrSeed
          default: 0xfd4a9945f60e3b08049d518f068aeb3c4dd55dadf9d4564c1c423c86671d455619980f46
          randwidth: 288
        }
        {
          name: RndCnstLfsrPerm
          desc: Compile-time random permutation for PRNG output
          type: kmac_pkg::lfsr_perm_t
          randcount: 800
          randtype: perm
          name_top: RndCnstKmacLfsrPerm
          default: 0xaa1370baef7c6dc84ef2c64a96d2ec1d22cb76568e02229e096e929990f030e21b320eafac46429b6d65d5c456681c054d9d369af45a3db7cfe49e39238524b4bb12d1f6780d9b5bd4bce94e0075a82f1a49a41f1b848779e1787f55eb39741e499bb800ba6ac9a1eb2918d7a037a6a659bc03530617a60aaec13c74453214b43274600d1564949722d441987a8e6161cc27ac98d97c4e6cd70d647565b3bd01151fca9a027211b765f08c13e01a5337584471879eed1952a1596497fcfb7d6ca7e4fc61a6c2364f362799063c48f0b9a5065d871559355aca6ba2f63d4ce1ec417283e0219718b065488a031c1192ab6642d719e5669089343b6cb0d6084994421c56157b1207e91a6f2c3605475a5b7afd0a0a65705e319ba0869704a8ce7a7d5b902f5be9d6b9ae233009872b2c489627d31744eb5fc5f80710535e20a90b7712a6386c7b5a4bc0d29feb4049ee316c84921eb01d88d549381cdbd27da7a2b0cab3572af1baedac0b04a00a2eaf998e7c5802c2c6cf388c02bde32bacb1b57e709324b95a26d89b5d85a96de1c162c467798afc1ae3e5e56816a6087c5e2255086ad385e0f6fa581e219a107f65252304ad8186a9d4bd13df2096d4110abaf7070d5303ce1b1a2343c9cf659b82fd00a8b149113da9d4043420170aa2841963c8262a8bb911d0588844c1a43d18921262f8fdab6c560ec22dd70ac66b35a66a48ca132e533d2c6c4cdb8e4320cee22d09bc5cb356e18b9c469c3a3418bc2992931638523203ad2194f14d9b99c11918c7e005ef0120c37c87014a002c433960d09e6780283076599c446c204db1c2331aeac0b1367018740de141a85df098a49d28cf685a2278551272f8391d479c24b40a81224a940b27984e7159fc6ac16b8ff969ad76d4f3b15dbfe5f108b8412423e27603c8f40c402f28d916d64eafda51a92b31cc06db1f1b60d87d4feba6ed346a9ac6ac8c40b0f89303a5522ae4989a94e28a3f82d579e921a741f748c766c1b0a22ab9cb52cced686aa620264787a2197557ed518095b64108a0760e1daa329c11d55448598bcd491f005cc1c51967791660fd173eb0c77c1ec5d7b50544a3ab75b92b811e07e1a21bd919f8b643a2338ef7adaa04cc11009dd3846775dde7d96c64c5bb6afe6ff18517054503d25ea9324c2c594a0d014898d772685bec8573a901d4302964b24a98174f912a463657a1cd486c2963115481433a218cbacf78cee015d5881e8fad4db6cebca26828413c0c4398dcd369a55b60b95cac67faae3d24e9cd050af0ea0072c78818821149490ae0cba1d3ba18dc3a85565618bce279c9c72d16da468aa92937ee993a1f3508808ec3c9797d4445119a6124d6f87681c7e25586977d1a3210157dc9180d434563a14dd3
          randwidth: 8000
        }
        {
          name: RndCnstBufferLfsrSeed
          desc: Compile-time random data for PRNG buffer default seed
          type: kmac_pkg::buffer_lfsr_seed_t
          randcount: 800
          randtype: data
          name_top: RndCnstKmacBufferLfsrSeed
          default: 0xe5a7cbfb991d04e5606487d483076e0167a8c32fcdb631861c7b35e8764001c6ff68e40fc9e5f5d060464b9cca4196c557cea57e4d976667ead9324073161de685d85f592bada0bbc98a3e61201a2836dca33964f4209eb0a6207060617324aa41418492
          randwidth: 800
        }
        {
          name: RndCnstMsgPerm
          desc: Compile-time random permutation for LFSR Message output
          type: kmac_pkg::msg_perm_t
          randcount: 64
          randtype: perm
          name_top: RndCnstKmacMsgPerm
          default: 0xa41446d6a68d3268186dd3e855487e93c127eeb1f900b0b66784b139696eeb38f75e2b0ab5c210c1ed3f16fc9ff490d3
          randwidth: 384
        }
      ]
    }
    {
      name: otbn
      type: otbn
      base_addrs:
      {
        null:
        {
          hart: 0x40130000
        }
      }
      memory: {}
      param_list:
      [
        {
          name: RndCnstUrndPrngSeed
          desc: Default seed of the PRNG used for URND.
          type: otbn_pkg::urnd_prng_seed_t
          randcount: 288
          randtype: data
          name_top: RndCnstOtbnUrndPrngSeed
          default: 0xbab173198bdff759a49cb9f6383b8609a1a3e9b32aca014a51ed3d61ac10ea4225224cee
          randwidth: 288
        }
        {
          name: RndCnstBnMacUrndPerm
          desc: Compile-time random permutation for URND permutation in BN MAC.
          type: otbn_pkg::bn_mac_urnd_perm_t
          randcount: 256
          randtype: perm
          name_top: RndCnstOtbnBnMacUrndPerm
          default: 0x42503d4567ccbb6cf303604f27a9569135cd8dd4d65746f99c2cc29f58d1ce83dc3fb1cb3c412a8c84ae3362e6657053343a3b4c47e451b099795bf7e7a012b8322b7521f507fe68e0d7c3ed087114c58f5f44aabe3eba02d3d29aea1cf0da202e1ec91a40807ad8b9a72df474dfcfbc19fd178885eceb2f38c0b5fc984e64667b6d1525b36389faee3718556b1bd00fc41130788e8b69941da8875ee810f80097a39249db90c80ec77d22a50a4a8a26e3dd31a4246e4dad050dcaf1a6a15cace948726116e17cafbd6a0bc61f9573b4c128a2d59b52939e09fb43e2f254ff13d9043981767e5ae50659b7866f360cabef4bb6f6825d7f2996b2de7701239dbf
          randwidth: 2048
        }
        {
          name: RndCnstOtbnKey
          desc: Compile-time random reset value for IMem/DMem scrambling key.
          type: otp_ctrl_pkg::otbn_key_t
          randcount: 128
          randtype: data
          name_top: RndCnstOtbnOtbnKey
          default: 0xd16a99db9d0330b31baf54a8940b126d
          randwidth: 128
        }
        {
          name: RndCnstOtbnNonce
          desc: Compile-time random reset value for IMem/DMem scrambling nonce.
          type: otp_ctrl_pkg::otbn_nonce_t
          randcount: 64
          randtype: data
          name_top: RndCnstOtbnOtbnNonce
          default: 0xe072d494ef5120fb
          randwidth: 64
        }
      ]
    }
    {
      name: keymgr_dpe
      type: keymgr_dpe
      base_addrs:
      {
        null:
        {
          hart: 0x40140000
        }
      }
      memory: {}
      param_list:
      [
        {
          name: RndCnstLfsrSeed
          desc: Compile-time random bits for initial LFSR seed
          type: keymgr_pkg::lfsr_seed_t
          randcount: 64
          randtype: data
          name_top: RndCnstKeymgrDpeLfsrSeed
          default: 0x35da1e6d559a25e0
          randwidth: 64
        }
        {
          name: RndCnstLfsrPerm
          desc: Compile-time random permutation for LFSR output
          type: keymgr_pkg::lfsr_perm_t
          randcount: 64
          randtype: perm
          name_top: RndCnstKeymgrDpeLfsrPerm
          default: 0xa199948b9ee472a6812ccac3188a51c4e7e31009cae935cd8180b587f4b4dbd573772f1bf9e2509475addcfc05e2cbaf
          randwidth: 384
        }
        {
          name: RndCnstRandPerm
          desc: Compile-time random permutation for entropy used in share overriding
          type: keymgr_pkg::rand_perm_t
          randcount: 32
          randtype: perm
          name_top: RndCnstKeymgrDpeRandPerm
          default: 0x8ddbe992c7ee7654a14337315fb1d09680f12c34
          randwidth: 160
        }
        {
          name: RndCnstRevisionSeed
          desc: Compile-time random bits for revision seed
          type: keymgr_pkg::seed_t
          randcount: 256
          randtype: data
          name_top: RndCnstKeymgrDpeRevisionSeed
          default: 0xd94ac694d9853d858477c8f5a764ee90111a60e23455474bf57d68da8327a8fd
          randwidth: 256
        }
        {
          name: RndCnstSoftOutputSeed
          desc: Compile-time random bits for software generation seed
          type: keymgr_pkg::seed_t
          randcount: 256
          randtype: data
          name_top: RndCnstKeymgrDpeSoftOutputSeed
          default: 0x2dd2ec49940d52b75f45ead9265b4712dc9bd57f6cf7a2e2b5b64795de1bfce9
          randwidth: 256
        }
        {
          name: RndCnstHardOutputSeed
          desc: Compile-time random bits for hardware generation seed
          type: keymgr_pkg::seed_t
          randcount: 256
          randtype: data
          name_top: RndCnstKeymgrDpeHardOutputSeed
          default: 0x711343233f0cf41dad39273dea563d41782a4c528552260e413bb7d3f9ccf9d8
          randwidth: 256
        }
        {
          name: RndCnstAesSeed
          desc: Compile-time random bits for generation seed when aes destination selected
          type: keymgr_pkg::seed_t
          randcount: 256
          randtype: data
          name_top: RndCnstKeymgrDpeAesSeed
          default: 0xd3123b144b65364f45239b1712485247595ec3b88dfbabbf99969ceab0691780
          randwidth: 256
        }
        {
          name: RndCnstKmacSeed
          desc: Compile-time random bits for generation seed when kmac destination selected
          type: keymgr_pkg::seed_t
          randcount: 256
          randtype: data
          name_top: RndCnstKeymgrDpeKmacSeed
          default: 0x2cacd5762f634c14b36e8772d67f9071b12dc05459b825dedefd386272a32c2d
          randwidth: 256
        }
        {
          name: RndCnstOtbnSeed
          desc: Compile-time random bits for generation seed when otbn destination selected
          type: keymgr_pkg::seed_t
          randcount: 256
          randtype: data
          name_top: RndCnstKeymgrDpeOtbnSeed
          default: 0xb89e62f7c6c8310d9e08b3ff3b8390db75ef94dac87b92fdfc150c6156628c4a
          randwidth: 256
        }
        {
          name: RndCnstNoneSeed
          desc: Compile-time random bits for generation seed when no destination selected
          type: keymgr_pkg::seed_t
          randcount: 256
          randtype: data
          name_top: RndCnstKeymgrDpeNoneSeed
          default: 0xa2cea5dba9f3180c48359728441317c074f52708cd3dcbbddb73da690cc28200
          randwidth: 256
        }
      ]
    }
    {
      name: csrng
      type: csrng
      base_addrs:
      {
        null:
        {
          hart: 0x40150000
        }
      }
      memory: {}
      param_list:
      [
        {
          name: RndCnstCsKeymgrDivNonProduction
          desc: Compile-time random bits for csrng state group diversification value
          type: csrng_pkg::cs_keymgr_div_t
          randcount: 384
          randtype: data
          name_top: RndCnstCsrngCsKeymgrDivNonProduction
          default: 0x849d8ae10f42bf8ae019ca47440f207c421e5fcc4b4e3f26efd44f160aab7cfb11aa1cd334d52be33950bff9cb53080d
          randwidth: 384
        }
        {
          name: RndCnstCsKeymgrDivProduction
          desc: Compile-time random bits for csrng state group diversification value
          type: csrng_pkg::cs_keymgr_div_t
          randcount: 384
          randtype: data
          name_top: RndCnstCsrngCsKeymgrDivProduction
          default: 0x35eff5128e07f55944d5951f2a38a5583629446361d8a4a42123e6b0b81867f5745f26856d0f9c3d99166e01edd5b864
          randwidth: 384
        }
      ]
    }
    {
      name: sram_ctrl_main
      type: sram_ctrl
      base_addrs:
      {
        regs:
        {
          hart: 0x40200000
        }
        ram:
        {
          hart: 0x10000000
        }
      }
      memory:
      {
        ram:
        {
          label: ram_main
          swaccess: rw
          data_intg_passthru: "true"
          exec: True
          byte_write: True
          size: 0x30000
        }
      }
      param_list:
      [
        {
          name: RndCnstSramKey
          desc: Compile-time random reset value for SRAM scrambling key.
          type: otp_ctrl_pkg::sram_key_t
          randcount: 128
          randtype: data
          name_top: RndCnstSramCtrlMainSramKey
          default: 0x8771a4e58512eaa46ee7dc269ce2f2f6
          randwidth: 128
        }
        {
          name: RndCnstSramNonce
          desc: Compile-time random reset value for SRAM scrambling nonce.
          type: otp_ctrl_pkg::sram_nonce_t
          randcount: 128
          randtype: data
          name_top: RndCnstSramCtrlMainSramNonce
          default: 0xe7b95767f1d20123ae962a003e30c2a8
          randwidth: 128
        }
        {
          name: RndCnstLfsrSeed
          desc: Compile-time random bits for initial LFSR seed
          type: sram_ctrl_pkg::lfsr_seed_t
          randcount: 64
          randtype: data
          name_top: RndCnstSramCtrlMainLfsrSeed
          default: 0x942f27c4ca21c632
          randwidth: 64
        }
        {
          name: RndCnstLfsrPerm
          desc: Compile-time random permutation for LFSR output
          type: sram_ctrl_pkg::lfsr_perm_t
          randcount: 64
          randtype: perm
          name_top: RndCnstSramCtrlMainLfsrPerm
          default: 0x6fcc7a14de3ea77fd25a6ef304a0b68da66d218730abd2d780e461d40564774a0c525b13787acf4062439e2c84bf9b9f
          randwidth: 384
        }
      ]
    }
    {
      name: rom_ctrl
      type: rom_ctrl
      base_addrs:
      {
        rom:
        {
          hart: 0x00040000
        }
        regs:
        {
          hart: 0x40210000
        }
      }
      memory:
      {
        rom:
        {
          label: rom
          swaccess: ro
          data_intg_passthru: True
          exec: True
          byte_write: False
          size: 0x20000
        }
      }
      param_list:
      [
        {
          name: RndCnstScrNonce
          desc: Fixed nonce used for address / data scrambling
          type: bit [63:0]
          randcount: 64
          randtype: data
          name_top: RndCnstRomCtrlScrNonce
          default: 0x57bb84a905b2c5f9
          randwidth: 64
        }
        {
          name: RndCnstScrKey
          desc: Randomised constant used as a scrambling key for ROM data
          type: bit [127:0]
          randcount: 128
          randtype: data
          name_top: RndCnstRomCtrlScrKey
          default: 0xc732916d3f0a01064f240ea0465a1689
          randwidth: 128
        }
      ]
    }
    {
      name: rv_core_ibex
      type: rv_core_ibex
      base_addrs:
      {
        cfg:
        {
          hart: 0x40220000
        }
      }
      memory: {}
      param_list:
      [
        {
          name: RndCnstLfsrSeed
          desc: Default seed of the PRNG used for random instructions.
          type: ibex_pkg::lfsr_seed_t
          randcount: 32
          randtype: data
          name_top: RndCnstRvCoreIbexLfsrSeed
          default: 0xa37bb88
          randwidth: 32
        }
        {
          name: RndCnstLfsrPerm
          desc: Permutation applied to the LFSR of the PRNG used for random instructions.
          type: ibex_pkg::lfsr_perm_t
          randcount: 32
          randtype: perm
          name_top: RndCnstRvCoreIbexLfsrPerm
          default: 0xcb1bc7101e41623a48ebae3aa0ff5bb1a134dde2
          randwidth: 160
        }
        {
          name: RndCnstIbexKey
          desc: Default icache scrambling key
          type: logic [ibex_pkg::SCRAMBLE_KEY_W-1:0]
          randcount: 128
          randtype: data
          name_top: RndCnstRvCoreIbexIbexKey
          default: 0x597635d3effef7c250098fb964be41d6
          randwidth: 128
        }
        {
          name: RndCnstIbexNonce
          desc: Default icache scrambling nonce
          type: logic [ibex_pkg::SCRAMBLE_NONCE_W-1:0]
          randcount: 64
          randtype: data
          name_top: RndCnstRvCoreIbexIbexNonce
          default: 0x92b97c1669f1994b
          randwidth: 64
        }
      ]
      template_type: rv_core_ibex
    }
    {
      name: alert_handler
      type: alert_handler
      base_addrs:
      {
        null:
        {
          hart: 0x41040000
        }
      }
      memory: {}
      param_list:
      [
        {
          name: RndCnstLfsrSeed
          desc: Compile-time random bits for initial LFSR seed
          type: alert_handler_pkg::lfsr_seed_t
          randcount: 32
          randtype: data
          name_top: RndCnstAlertHandlerLfsrSeed
          default: 0x9663dfcc
          randwidth: 32
        }
        {
          name: RndCnstLfsrPerm
          desc: Compile-time random permutation for LFSR output
          type: alert_handler_pkg::lfsr_perm_t
          randcount: 32
          randtype: perm
          name_top: RndCnstAlertHandlerLfsrPerm
          default: 0xbe447c37400b3f389972ed4a3a121bf3d2e5591c
          randwidth: 160
        }
      ]
      template_type: alert_handler
    }
    {
      name: sram_ctrl_ret
      type: sram_ctrl
      base_addrs:
      {
        regs:
        {
          hart: 0x41050000
        }
        ram:
        {
          hart: 0x41100000
        }
      }
      memory:
      {
        ram:
        {
          label: ram_ret_aon
          swaccess: rw
          data_intg_passthru: "true"
          exec: True
          byte_write: True
          size: 0x2000
        }
      }
      param_list:
      [
        {
          name: RndCnstSramKey
          desc: Compile-time random reset value for SRAM scrambling key.
          type: otp_ctrl_pkg::sram_key_t
          randcount: 128
          randtype: data
          name_top: RndCnstSramCtrlRetSramKey
          default: 0x1b20884604567bc0249e2d8ab794a763
          randwidth: 128
        }
        {
          name: RndCnstSramNonce
          desc: Compile-time random reset value for SRAM scrambling nonce.
          type: otp_ctrl_pkg::sram_nonce_t
          randcount: 128
          randtype: data
          name_top: RndCnstSramCtrlRetSramNonce
          default: 0x3d9c6ecf883c940f9c5210b3c5863384
          randwidth: 128
        }
        {
          name: RndCnstLfsrSeed
          desc: Compile-time random bits for initial LFSR seed
          type: sram_ctrl_pkg::lfsr_seed_t
          randcount: 64
          randtype: data
          name_top: RndCnstSramCtrlRetLfsrSeed
          default: 0x2bdf1122beb15ea
          randwidth: 64
        }
        {
          name: RndCnstLfsrPerm
          desc: Compile-time random permutation for LFSR output
          type: sram_ctrl_pkg::lfsr_perm_t
          randcount: 64
          randtype: perm
          name_top: RndCnstSramCtrlRetLfsrPerm
          default: 0x98df8a3a09f254825fb31136fc3054ad27798b46689424245f345685a32316e73ad693dbbed198ede1fddd3f38a80c0b
          randwidth: 384
        }
      ]
    }
  ]
}
