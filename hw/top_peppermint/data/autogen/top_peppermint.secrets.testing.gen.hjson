// Copyright lowRISC contributors (OpenTitan project).
// Licensed under the Apache License, Version 2.0, see LICENSE for details.
// SPDX-License-Identifier: Apache-2.0
//
// ------------------- W A R N I N G: A U T O - G E N E R A T E D   C O D E !! -------------------//
// PLEASE DO NOT HAND-EDIT THIS FILE. IT HAS BEEN AUTO-GENERATED WITH THE FOLLOWING COMMAND:
// util/topgen.py -t hw/top_peppermint/data/top_peppermint.hjson
//                -o hw/top_peppermint/
{
  seed:
  {
    topgen_seed:
    {
      seed_mode: testing
      value: 51451787542291517751888767411848989252412020777091149863881806945777355144337
    }
    otp_img_seed:
    {
      seed_mode: testing
      value: 24868028277047070845280224376993946593238997617476146683055290474876205000801
    }
    lc_ctrl_seed:
    {
      seed_mode: testing
      value: 49841089124658132456165265978197681960561948696349021308850918515200439523606
    }
  }
  module:
  [
    {
      name: alert_handler
      type: alert_handler
      base_addrs:
      {
        null:
        {
          hart: 0x40450000
        }
      }
      memory: {}
      param_list:
      [
        {
          name: RndCnstLfsrSeed
          desc: Compile-time random bits for initial LFSR seed
          type: alert_handler_pkg::lfsr_seed_t
          randcount: 32
          randtype: data
          name_top: RndCnstAlertHandlerLfsrSeed
          default: 0xe6bc3ef8
          randwidth: 32
        }
        {
          name: RndCnstLfsrPerm
          desc: Compile-time random permutation for LFSR output
          type: alert_handler_pkg::lfsr_perm_t
          randcount: 32
          randtype: perm
          name_top: RndCnstAlertHandlerLfsrPerm
          default: 0xab34758a3dd8e93814cf24936e073e53b08b81bf
          randwidth: 160
        }
      ]
      template_type: alert_handler
    }
    {
      name: sram_ctrl_ret_aon
      type: sram_ctrl
      base_addrs:
      {
        regs:
        {
          hart: 0x40460000
        }
        ram:
        {
          hart: 0x40470000
        }
      }
      memory:
      {
        ram:
        {
          label: ram_ret_aon
          swaccess: rw
          data_intg_passthru: "true"
          exec: True
          byte_write: True
          size: 0x2000
        }
      }
      param_list:
      [
        {
          name: RndCnstSramKey
          desc: Compile-time random reset value for SRAM scrambling key.
          type: otp_ctrl_pkg::sram_key_t
          randcount: 128
          randtype: data
          name_top: RndCnstSramCtrlRetAonSramKey
          default: 0x5fc12be3c5333d77aee81229ad96c8c5
          randwidth: 128
        }
        {
          name: RndCnstSramNonce
          desc: Compile-time random reset value for SRAM scrambling nonce.
          type: otp_ctrl_pkg::sram_nonce_t
          randcount: 128
          randtype: data
          name_top: RndCnstSramCtrlRetAonSramNonce
          default: 0x96eda91a2485301a48907c59639294c3
          randwidth: 128
        }
        {
          name: RndCnstLfsrSeed
          desc: Compile-time random bits for initial LFSR seed
          type: sram_ctrl_pkg::lfsr_seed_t
          randcount: 64
          randtype: data
          name_top: RndCnstSramCtrlRetAonLfsrSeed
          default: 0x3b5f713fdefa9c76
          randwidth: 64
        }
        {
          name: RndCnstLfsrPerm
          desc: Compile-time random permutation for LFSR output
          type: sram_ctrl_pkg::lfsr_perm_t
          randcount: 64
          randtype: perm
          name_top: RndCnstSramCtrlRetAonLfsrPerm
          default: 0xe6a5d33d9f50f2138c074bf835a6250d27301ff896eac015b85ed4fb1deb7d180ab75a1b2369a31a7cdd08ba4425e932
          randwidth: 384
        }
      ]
    }
    {
      name: otp_ctrl
      type: otp_ctrl
      base_addrs:
      {
        core:
        {
          hart: 0x30130000
        }
      }
      memory: {}
      param_list:
      [
        {
          name: RndCnstLfsrSeed
          desc: Compile-time random bits for initial LFSR seed
          type: otp_ctrl_top_specific_pkg::lfsr_seed_t
          randcount: 40
          randtype: data
          name_top: RndCnstOtpCtrlLfsrSeed
          default: 0xe951afc889
          randwidth: 40
        }
        {
          name: RndCnstLfsrPerm
          desc: Compile-time random permutation for LFSR output
          type: otp_ctrl_top_specific_pkg::lfsr_perm_t
          randcount: 40
          randtype: perm
          name_top: RndCnstOtpCtrlLfsrPerm
          default: 0x78869d8db02640b30d9df38765244a0d409790684f165058720893115589
          randwidth: 240
        }
        {
          name: RndCnstScrmblKeyInit
          desc: Compile-time random permutation for scrambling key/nonce register reset value
          type: otp_ctrl_top_specific_pkg::scrmbl_key_init_t
          randcount: 256
          randtype: data
          name_top: RndCnstOtpCtrlScrmblKeyInit
          default: 0x253ddfd78e689fd16d99b84890c036f4e8d7c83b63acda019f8d7eda05d5a9df
          randwidth: 256
        }
        {
          name: RndCnstScrmblKey0
          desc: Compile-time scrambling key
          type: otp_ctrl_top_specific_pkg::key_t
          randcount: 128
          randtype: extdata
          name_top: RndCnstOtpCtrlScrmblKey0
          default: 0x98935387d84d189e94d201d4ca6d258f
          randwidth: 128
        }
        {
          name: RndCnstScrmblKey1
          desc: Compile-time scrambling key
          type: otp_ctrl_top_specific_pkg::key_t
          randcount: 128
          randtype: extdata
          name_top: RndCnstOtpCtrlScrmblKey1
          default: 0x957c6a0c9c087e73f96d33de76437066
          randwidth: 128
        }
        {
          name: RndCnstScrmblKey2
          desc: Compile-time scrambling key
          type: otp_ctrl_top_specific_pkg::key_t
          randcount: 128
          randtype: extdata
          name_top: RndCnstOtpCtrlScrmblKey2
          default: 0xe6efaa7743364fabfdadba1867aef4a5
          randwidth: 128
        }
        {
          name: RndCnstScrmblKey3
          desc: Compile-time scrambling key
          type: otp_ctrl_top_specific_pkg::key_t
          randcount: 128
          randtype: extdata
          name_top: RndCnstOtpCtrlScrmblKey3
          default: 0x25d3438c679bc5e1e95b11249ca35dde
          randwidth: 128
        }
        {
          name: RndCnstDigestConst0
          desc: Compile-time digest const
          type: otp_ctrl_top_specific_pkg::digest_const_t
          randcount: 128
          randtype: extdata
          name_top: RndCnstOtpCtrlDigestConst0
          default: 0x32067e1786b83222d00054b2af120ff8
          randwidth: 128
        }
        {
          name: RndCnstDigestConst1
          desc: Compile-time digest const
          type: otp_ctrl_top_specific_pkg::digest_const_t
          randcount: 128
          randtype: extdata
          name_top: RndCnstOtpCtrlDigestConst1
          default: 0x86a0b2454cfa25b23b692148e188c5ca
          randwidth: 128
        }
        {
          name: RndCnstDigestIV0
          desc: Compile-time digest initial vector
          type: otp_ctrl_top_specific_pkg::digest_iv_t
          randcount: 64
          randtype: extdata
          name_top: RndCnstOtpCtrlDigestIV0
          default: 0x49b7c7cd1734b80e
          randwidth: 64
        }
        {
          name: RndCnstDigestIV1
          desc: Compile-time digest initial vector
          type: otp_ctrl_top_specific_pkg::digest_iv_t
          randcount: 64
          randtype: extdata
          name_top: RndCnstOtpCtrlDigestIV1
          default: 0x1ae014cefd7de2cb
          randwidth: 64
        }
        {
          name: RndCnstPartInvDefault
          desc: OTP invalid partition default for buffered partitions
          type: logic [39807:0]
          randcount: 39808
          randtype: extdata
          name_top: RndCnstOtpCtrlPartInvDefault
          default:
          [
            {
              size: 704
              items:
              [
                {
                  size: 320
                  inv_default: 508406651299787982309904825443985373106236637081727939090585644961445206666689630393817246511712
                }
                {
                  size: 384
                  inv_default: 34765581757057702526568169959179506991796799849684129792408382543682161064351438550357191642801906499564079722040959
                }
              ]
            }
            {
              size: 384
              items:
              [
                {
                  size: 64
                  inv_default: 0
                }
                {
                  size: 64
                  inv_default: 10297274993151818246
                }
                {
                  size: 256
                  inv_default: 10206999105613237488305124545664851698610302080045852370886952986780297145526
                }
              ]
            }
            {
              size: 1024
              items:
              [
                {
                  size: 64
                  inv_default: 0
                }
                {
                  size: 64
                  inv_default: 16862586926326724172
                }
                {
                  size: 256
                  inv_default: 63999019030607151289909366880942569362330468042440373196189507388017079630937
                }
                {
                  size: 256
                  inv_default: 81109909720667310531206694470923378649726943238131960830210841988782597012480
                }
                {
                  size: 256
                  inv_default: 58428367318477997995158430436185008200278041856729653820014384131744449381794
                }
                {
                  size: 128
                  inv_default: 257151471457813701810792034009910885873
                }
              ]
            }
            {
              size: 256
              items:
              [
                {
                  size: 64
                  inv_default: 0
                }
                {
                  size: 64
                  inv_default: 12446391818523284464
                }
                {
                  size: 128
                  inv_default: 119626835793529483393158377097849370351
                }
              ]
            }
            {
              size: 384
              items:
              [
                {
                  size: 64
                  inv_default: 0
                }
                {
                  size: 64
                  inv_default: 10065874593229139721
                }
                {
                  size: 128
                  inv_default: 8049454917427216925997827152549284667
                }
                {
                  size: 128
                  inv_default: 191985393975828609903709283012653827085
                }
              ]
            }
            {
              size: 128
              items:
              [
                {
                  size: 64
                  inv_default: 9673330360152269864
                }
                {
                  comment: unallocated space
                  size: 16
                  inv_default: 0
                }
                {
                  size: 8
                  inv_default: 105
                }
                {
                  size: 8
                  inv_default: 105
                }
                {
                  size: 32
                  inv_default: 0
                }
              ]
            }
            {
              size: 576
              items:
              [
                {
                  size: 64
                  inv_default: 8821601860276922949
                }
                {
                  size: 256
                  inv_default: 89960518397345998442210387957448911146016937697982416014732294109643662651482
                }
                {
                  size: 256
                  inv_default: 84636775181865843423447751136542243067225345129144998513113609321933118751675
                }
              ]
            }
            {
              size: 8192
              items:
              [
                {
                  size: 8192
                  inv_default: 0
                }
              ]
            }
            {
              size: 1088
              items:
              [
                {
                  size: 64
                  inv_default: 16898073465963608763
                }
                {
                  size: 1024
                  inv_default: 0
                }
              ]
            }
            {
              size: 1088
              items:
              [
                {
                  size: 64
                  inv_default: 14656815325044117528
                }
                {
                  size: 1024
                  inv_default: 0
                }
              ]
            }
            {
              size: 1088
              items:
              [
                {
                  size: 64
                  inv_default: 7544202290022723701
                }
                {
                  size: 1024
                  inv_default: 0
                }
              ]
            }
            {
              size: 1088
              items:
              [
                {
                  size: 64
                  inv_default: 6297967080745773217
                }
                {
                  size: 1024
                  inv_default: 0
                }
              ]
            }
            {
              size: 1088
              items:
              [
                {
                  size: 64
                  inv_default: 4275689744169575455
                }
                {
                  size: 1024
                  inv_default: 0
                }
              ]
            }
            {
              size: 1088
              items:
              [
                {
                  size: 64
                  inv_default: 10448767896760702259
                }
                {
                  size: 1024
                  inv_default: 0
                }
              ]
            }
            {
              size: 1088
              items:
              [
                {
                  size: 64
                  inv_default: 5650730686695884436
                }
                {
                  size: 1024
                  inv_default: 0
                }
              ]
            }
            {
              size: 1088
              items:
              [
                {
                  size: 64
                  inv_default: 4036071169128675423
                }
                {
                  size: 1024
                  inv_default: 0
                }
              ]
            }
            {
              size: 11392
              items:
              [
                {
                  size: 64
                  inv_default: 15819321713790451465
                }
                {
                  comment: unallocated space
                  size: 32
                  inv_default: 0
                }
                {
                  size: 6144
                  inv_default: 0
                }
                {
                  size: 1280
                  inv_default: 0
                }
                {
                  size: 1280
                  inv_default: 0
                }
                {
                  size: 1280
                  inv_default: 0
                }
                {
                  size: 32
                  inv_default: 0
                }
                {
                  size: 1280
                  inv_default: 0
                }
              ]
            }
            {
              size: 256
              items:
              [
                {
                  size: 128
                  inv_default: 0
                }
                {
                  size: 128
                  inv_default: 0
                }
              ]
            }
            {
              size: 4800
              items:
              [
                {
                  size: 64
                  inv_default: 4123931682964426286
                }
                {
                  size: 32
                  inv_default: 0
                }
                {
                  size: 32
                  inv_default: 0
                }
                {
                  size: 32
                  inv_default: 0
                }
                {
                  size: 32
                  inv_default: 0
                }
                {
                  size: 32
                  inv_default: 0
                }
                {
                  size: 32
                  inv_default: 0
                }
                {
                  size: 32
                  inv_default: 0
                }
                {
                  size: 32
                  inv_default: 0
                }
                {
                  size: 512
                  inv_default: 0
                }
                {
                  size: 128
                  inv_default: 0
                }
                {
                  size: 128
                  inv_default: 0
                }
                {
                  size: 224
                  inv_default: 0
                }
                {
                  size: 3360
                  inv_default: 0
                }
                {
                  size: 32
                  inv_default: 0
                }
                {
                  size: 32
                  inv_default: 0
                }
                {
                  size: 32
                  inv_default: 0
                }
                {
                  size: 32
                  inv_default: 0
                }
              ]
            }
            {
              size: 2496
              items:
              [
                {
                  size: 64
                  inv_default: 7512587968106004660
                }
                {
                  comment: unallocated space
                  size: 32
                  inv_default: 0
                }
                {
                  size: 32
                  inv_default: 0
                }
                {
                  size: 32
                  inv_default: 0
                }
                {
                  size: 32
                  inv_default: 0
                }
                {
                  size: 32
                  inv_default: 0
                }
                {
                  size: 32
                  inv_default: 0
                }
                {
                  size: 32
                  inv_default: 0
                }
                {
                  size: 32
                  inv_default: 0
                }
                {
                  size: 32
                  inv_default: 0
                }
                {
                  size: 32
                  inv_default: 0
                }
                {
                  size: 32
                  inv_default: 0
                }
                {
                  size: 32
                  inv_default: 0
                }
                {
                  size: 32
                  inv_default: 0
                }
                {
                  size: 32
                  inv_default: 0
                }
                {
                  size: 32
                  inv_default: 0
                }
                {
                  size: 32
                  inv_default: 0
                }
                {
                  size: 32
                  inv_default: 0
                }
                {
                  size: 32
                  inv_default: 0
                }
                {
                  size: 32
                  inv_default: 0
                }
                {
                  size: 32
                  inv_default: 0
                }
                {
                  size: 32
                  inv_default: 0
                }
                {
                  size: 32
                  inv_default: 0
                }
                {
                  size: 32
                  inv_default: 0
                }
                {
                  size: 32
                  inv_default: 0
                }
                {
                  size: 32
                  inv_default: 0
                }
                {
                  size: 32
                  inv_default: 0
                }
                {
                  size: 32
                  inv_default: 0
                }
                {
                  size: 32
                  inv_default: 0
                }
                {
                  size: 32
                  inv_default: 0
                }
                {
                  size: 64
                  inv_default: 0
                }
                {
                  size: 32
                  inv_default: 0
                }
                {
                  size: 64
                  inv_default: 0
                }
                {
                  size: 32
                  inv_default: 0
                }
                {
                  size: 32
                  inv_default: 0
                }
                {
                  size: 256
                  inv_default: 0
                }
                {
                  size: 32
                  inv_default: 0
                }
                {
                  size: 992
                  inv_default: 0
                }
              ]
            }
            {
              size: 512
              items:
              [
                {
                  size: 64
                  inv_default: 13995797430872360414
                }
                {
                  size: 448
                  inv_default: 0
                }
              ]
            }
          ]
          randwidth: 39808
        }
      ]
      template_type: otp_ctrl
      otp_mmap:
      {
        otp:
        {
          width: 2
          depth: 4096
          size: 8192
          addr_width: 12
          byte_addr_width: 13
        }
        scrambling:
        {
          key_size: 16
          iv_size: 8
          cnst_size: 16
          keys:
          [
            {
              name: Secret0Key
              value: 202807617200252840528729068358060549519
            }
            {
              name: Secret1Key
              value: 198700967116856651033054259582582616166
            }
            {
              name: Secret2Key
              value: 306966855438305588444436821114459452581
            }
            {
              name: Secret3Key
              value: 50278380526644206573154867505977843166
            }
          ]
          digests:
          [
            {
              name: CnstyDigest
              iv_value: 5311933969178343438
              cnst_value: 66495111017948470976885563649124601848
            }
            {
              name: SramDataKey
              iv_value: 1936570719018017483
              cnst_value: 178950934692020233087936965387133437386
            }
          ]
          num_keys: 4
          num_digests: 2
        }
        partitions:
        [
          {
            name: VENDOR_TEST
            variant: Unbuffered
            absorb: false
            secret: false
            sw_digest: true
            hw_digest: false
            write_lock: Digest
            read_lock: CSR
            key_sel: NoKey
            integrity: false
            bkout_type: false
            zeroizable: false
            skip_sw_header: true
            items:
            [
              {
                name: SCRATCH
                size: 56
                isdigest: false
                iszer: false
                ismubi: false
                iskeymgr_creator: false
                iskeymgr_owner: false
                inv_default: 0
                offset: 0
              }
              {
                name: VENDOR_TEST_DIGEST
                size: 8
                offset: 56
                ismubi: false
                isdigest: true
                iszer: false
                inv_default: 13995797430872360414
                iskeymgr_creator: false
                iskeymgr_owner: false
              }
            ]
            desc:
              '''
              Vendor test partition.
              This is reserved for manufacturing smoke checks. The OTP wrapper
              control logic inside prim_otp is allowed to read/write to this
              region. ECC uncorrectable errors seen on the functional prim_otp
              interface will not lead to an alert for this partition.
              Instead, such errors will be reported as correctable ECC errors.
              '''
            iskeymgr_creator: false
            iskeymgr_owner: false
            ignore_read_lock_in_rma: false
            size: 64
            offset: 0
          }
          {
            name: CREATOR_SW_CFG
            variant: Unbuffered
            absorb: false
            secret: false
            sw_digest: true
            hw_digest: false
            write_lock: Digest
            read_lock: CSR
            key_sel: NoKey
            integrity: true
            bkout_type: false
            zeroizable: false
            items:
            [
              {
                name: CREATOR_SW_CFG_AST_CFG
                size: 124
                isdigest: false
                iszer: false
                ismubi: false
                iskeymgr_creator: false
                iskeymgr_owner: false
                inv_default: 0
                offset: 64
              }
              {
                name: CREATOR_SW_CFG_AST_INIT_EN
                size: 4
                isdigest: false
                iszer: false
                ismubi: false
                iskeymgr_creator: false
                iskeymgr_owner: false
                inv_default: 0
                offset: 188
              }
              {
                name: CREATOR_SW_CFG_OVERRIDES
                size: 32
                isdigest: false
                iszer: false
                ismubi: false
                iskeymgr_creator: false
                iskeymgr_owner: false
                inv_default: 0
                offset: 192
              }
              {
                name: CREATOR_SW_CFG_ROM_EXT_SKU
                size: 4
                isdigest: false
                iszer: false
                ismubi: false
                iskeymgr_creator: false
                iskeymgr_owner: false
                inv_default: 0
                offset: 224
              }
              {
                name: CREATOR_SW_CFG_SIGVERIFY_RSA_MOD_EXP_IBEX_EN
                size: 4
                isdigest: false
                iszer: false
                ismubi: false
                iskeymgr_creator: false
                iskeymgr_owner: false
                inv_default: 0
                offset: 228
              }
              {
                name: CREATOR_SW_CFG_SIGVERIFY_RSA_KEY_EN
                size: 8
                isdigest: false
                iszer: false
                ismubi: false
                iskeymgr_creator: false
                iskeymgr_owner: false
                inv_default: 0
                offset: 232
              }
              {
                name: CREATOR_SW_CFG_SIGVERIFY_SPX_EN
                size: 4
                isdigest: false
                iszer: false
                ismubi: false
                iskeymgr_creator: false
                iskeymgr_owner: false
                inv_default: 0
                offset: 240
              }
              {
                name: CREATOR_SW_CFG_SIGVERIFY_SPX_KEY_EN
                size: 8
                isdigest: false
                iszer: false
                ismubi: false
                iskeymgr_creator: false
                iskeymgr_owner: false
                inv_default: 0
                offset: 244
              }
              {
                name: CREATOR_SW_CFG_FLASH_DATA_DEFAULT_CFG
                size: 4
                isdigest: false
                iszer: false
                ismubi: false
                iskeymgr_creator: false
                iskeymgr_owner: false
                inv_default: 0
                offset: 252
              }
              {
                name: CREATOR_SW_CFG_FLASH_INFO_BOOT_DATA_CFG
                size: 4
                isdigest: false
                iszer: false
                ismubi: false
                iskeymgr_creator: false
                iskeymgr_owner: false
                inv_default: 0
                offset: 256
              }
              {
                name: CREATOR_SW_CFG_FLASH_HW_INFO_CFG_OVERRIDE
                size: 4
                isdigest: false
                iszer: false
                ismubi: false
                iskeymgr_creator: false
                iskeymgr_owner: false
                inv_default: 0
                offset: 260
              }
              {
                name: CREATOR_SW_CFG_RNG_EN
                size: 4
                isdigest: false
                iszer: false
                ismubi: false
                iskeymgr_creator: false
                iskeymgr_owner: false
                inv_default: 0
                offset: 264
              }
              {
                name: CREATOR_SW_CFG_JITTER_EN
                size: 4
                isdigest: false
                iszer: false
                ismubi: false
                iskeymgr_creator: false
                iskeymgr_owner: false
                inv_default: 0
                offset: 268
              }
              {
                name: CREATOR_SW_CFG_RET_RAM_RESET_MASK
                size: 4
                isdigest: false
                iszer: false
                ismubi: false
                iskeymgr_creator: false
                iskeymgr_owner: false
                inv_default: 0
                offset: 272
              }
              {
                name: CREATOR_SW_CFG_MANUF_STATE
                size: 4
                isdigest: false
                iszer: false
                ismubi: false
                iskeymgr_creator: false
                iskeymgr_owner: false
                inv_default: 0
                offset: 276
              }
              {
                name: CREATOR_SW_CFG_ROM_EXEC_EN
                size: 4
                isdigest: false
                iszer: false
                ismubi: false
                iskeymgr_creator: false
                iskeymgr_owner: false
                inv_default: 0
                offset: 280
              }
              {
                name: CREATOR_SW_CFG_CPUCTRL
                size: 4
                isdigest: false
                iszer: false
                ismubi: false
                iskeymgr_creator: false
                iskeymgr_owner: false
                inv_default: 0
                offset: 284
              }
              {
                name: CREATOR_SW_CFG_MIN_SEC_VER_ROM_EXT
                size: 4
                isdigest: false
                iszer: false
                ismubi: false
                iskeymgr_creator: false
                iskeymgr_owner: false
                inv_default: 0
                offset: 288
              }
              {
                name: CREATOR_SW_CFG_MIN_SEC_VER_BL0
                size: 4
                isdigest: false
                iszer: false
                ismubi: false
                iskeymgr_creator: false
                iskeymgr_owner: false
                inv_default: 0
                offset: 292
              }
              {
                name: CREATOR_SW_CFG_DEFAULT_BOOT_DATA_IN_PROD_EN
                size: 4
                isdigest: false
                iszer: false
                ismubi: false
                iskeymgr_creator: false
                iskeymgr_owner: false
                inv_default: 0
                offset: 296
              }
              {
                name: CREATOR_SW_CFG_RMA_SPIN_EN
                size: 4
                isdigest: false
                iszer: false
                ismubi: false
                iskeymgr_creator: false
                iskeymgr_owner: false
                inv_default: 0
                offset: 300
              }
              {
                name: CREATOR_SW_CFG_RMA_SPIN_CYCLES
                size: 4
                isdigest: false
                iszer: false
                ismubi: false
                iskeymgr_creator: false
                iskeymgr_owner: false
                inv_default: 0
                offset: 304
              }
              {
                name: CREATOR_SW_CFG_RNG_REPCNT_THRESHOLDS
                size: 4
                isdigest: false
                iszer: false
                ismubi: false
                iskeymgr_creator: false
                iskeymgr_owner: false
                inv_default: 0
                offset: 308
              }
              {
                name: CREATOR_SW_CFG_RNG_REPCNTS_THRESHOLDS
                size: 4
                isdigest: false
                iszer: false
                ismubi: false
                iskeymgr_creator: false
                iskeymgr_owner: false
                inv_default: 0
                offset: 312
              }
              {
                name: CREATOR_SW_CFG_RNG_ADAPTP_HI_THRESHOLDS
                size: 4
                isdigest: false
                iszer: false
                ismubi: false
                iskeymgr_creator: false
                iskeymgr_owner: false
                inv_default: 0
                offset: 316
              }
              {
                name: CREATOR_SW_CFG_RNG_ADAPTP_LO_THRESHOLDS
                size: 4
                isdigest: false
                iszer: false
                ismubi: false
                iskeymgr_creator: false
                iskeymgr_owner: false
                inv_default: 0
                offset: 320
              }
              {
                name: CREATOR_SW_CFG_RNG_BUCKET_THRESHOLDS
                size: 4
                isdigest: false
                iszer: false
                ismubi: false
                iskeymgr_creator: false
                iskeymgr_owner: false
                inv_default: 0
                offset: 324
              }
              {
                name: CREATOR_SW_CFG_RNG_MARKOV_HI_THRESHOLDS
                size: 4
                isdigest: false
                iszer: false
                ismubi: false
                iskeymgr_creator: false
                iskeymgr_owner: false
                inv_default: 0
                offset: 328
              }
              {
                name: CREATOR_SW_CFG_RNG_MARKOV_LO_THRESHOLDS
                size: 4
                isdigest: false
                iszer: false
                ismubi: false
                iskeymgr_creator: false
                iskeymgr_owner: false
                inv_default: 0
                offset: 332
              }
              {
                name: CREATOR_SW_CFG_RNG_EXTHT_HI_THRESHOLDS
                size: 4
                isdigest: false
                iszer: false
                ismubi: false
                iskeymgr_creator: false
                iskeymgr_owner: false
                inv_default: 0
                offset: 336
              }
              {
                name: CREATOR_SW_CFG_RNG_EXTHT_LO_THRESHOLDS
                size: 4
                isdigest: false
                iszer: false
                ismubi: false
                iskeymgr_creator: false
                iskeymgr_owner: false
                inv_default: 0
                offset: 340
              }
              {
                name: CREATOR_SW_CFG_RNG_BOOT_ALERT_THRESHOLD
                size: 4
                isdigest: false
                iszer: false
                ismubi: false
                iskeymgr_creator: false
                iskeymgr_owner: false
                inv_default: 0
                offset: 344
              }
              {
                name: CREATOR_SW_CFG_RNG_FIPS_ALERT_THRESHOLD
                size: 4
                isdigest: false
                iszer: false
                ismubi: false
                iskeymgr_creator: false
                iskeymgr_owner: false
                inv_default: 0
                offset: 348
              }
              {
                name: CREATOR_SW_CFG_RNG_BOOT_CONFIG_DIGEST
                size: 4
                isdigest: false
                iszer: false
                ismubi: false
                iskeymgr_creator: false
                iskeymgr_owner: false
                inv_default: 0
                offset: 352
              }
              {
                name: CREATOR_SW_CFG_RNG_FIPS_CONFIG_DIGEST
                size: 4
                isdigest: false
                iszer: false
                ismubi: false
                iskeymgr_creator: false
                iskeymgr_owner: false
                inv_default: 0
                offset: 356
              }
              {
                name: CREATOR_SW_CFG_SRAM_KEY_RENEW_AND_INIT_EN
                size: 4
                isdigest: false
                iszer: false
                ismubi: false
                iskeymgr_creator: false
                iskeymgr_owner: false
                inv_default: 0
                offset: 360
              }
              {
                name: CREATOR_SW_CFG_DIGEST
                size: 8
                offset: 368
                ismubi: false
                isdigest: true
                iszer: false
                inv_default: 7512587968106004660
                iskeymgr_creator: false
                iskeymgr_owner: false
              }
            ]
            desc:
              '''
              Software configuration partition.
              This is for device-specific calibration data. For example, clock,
              LDO, RNG.
              '''
            iskeymgr_creator: false
            iskeymgr_owner: false
            ignore_read_lock_in_rma: false
            size: 312
            offset: 64
          }
          {
            name: OWNER_SW_CFG
            variant: Unbuffered
            absorb: false
            secret: false
            sw_digest: true
            hw_digest: false
            write_lock: Digest
            read_lock: CSR
            key_sel: NoKey
            integrity: true
            bkout_type: false
            zeroizable: false
            items:
            [
              {
                name: OWNER_SW_CFG_ROM_ERROR_REPORTING
                size: 4
                isdigest: false
                iszer: false
                ismubi: false
                iskeymgr_creator: false
                iskeymgr_owner: false
                inv_default: 0
                offset: 376
              }
              {
                name: OWNER_SW_CFG_ROM_BOOTSTRAP_DIS
                size: 4
                isdigest: false
                iszer: false
                ismubi: false
                iskeymgr_creator: false
                iskeymgr_owner: false
                inv_default: 0
                offset: 380
              }
              {
                name: OWNER_SW_CFG_ROM_ALERT_CLASS_EN
                size: 4
                isdigest: false
                iszer: false
                ismubi: false
                iskeymgr_creator: false
                iskeymgr_owner: false
                inv_default: 0
                offset: 384
              }
              {
                name: OWNER_SW_CFG_ROM_ALERT_ESCALATION
                size: 4
                isdigest: false
                iszer: false
                ismubi: false
                iskeymgr_creator: false
                iskeymgr_owner: false
                inv_default: 0
                offset: 388
              }
              {
                name: OWNER_SW_CFG_ROM_ALERT_CLASSIFICATION
                size: 420
                isdigest: false
                iszer: false
                ismubi: false
                iskeymgr_creator: false
                iskeymgr_owner: false
                inv_default: 0
                offset: 392
              }
              {
                name: OWNER_SW_CFG_ROM_LOCAL_ALERT_CLASSIFICATION
                size: 28
                isdigest: false
                iszer: false
                ismubi: false
                iskeymgr_creator: false
                iskeymgr_owner: false
                inv_default: 0
                offset: 812
              }
              {
                name: OWNER_SW_CFG_ROM_ALERT_ACCUM_THRESH
                size: 16
                isdigest: false
                iszer: false
                ismubi: false
                iskeymgr_creator: false
                iskeymgr_owner: false
                inv_default: 0
                offset: 840
              }
              {
                name: OWNER_SW_CFG_ROM_ALERT_TIMEOUT_CYCLES
                size: 16
                isdigest: false
                iszer: false
                ismubi: false
                iskeymgr_creator: false
                iskeymgr_owner: false
                inv_default: 0
                offset: 856
              }
              {
                name: OWNER_SW_CFG_ROM_ALERT_PHASE_CYCLES
                size: 64
                isdigest: false
                iszer: false
                ismubi: false
                iskeymgr_creator: false
                iskeymgr_owner: false
                inv_default: 0
                offset: 872
              }
              {
                name: OWNER_SW_CFG_ROM_ALERT_DIGEST_PROD
                size: 4
                isdigest: false
                iszer: false
                ismubi: false
                iskeymgr_creator: false
                iskeymgr_owner: false
                inv_default: 0
                offset: 936
              }
              {
                name: OWNER_SW_CFG_ROM_ALERT_DIGEST_PROD_END
                size: 4
                isdigest: false
                iszer: false
                ismubi: false
                iskeymgr_creator: false
                iskeymgr_owner: false
                inv_default: 0
                offset: 940
              }
              {
                name: OWNER_SW_CFG_ROM_ALERT_DIGEST_DEV
                size: 4
                isdigest: false
                iszer: false
                ismubi: false
                iskeymgr_creator: false
                iskeymgr_owner: false
                inv_default: 0
                offset: 944
              }
              {
                name: OWNER_SW_CFG_ROM_ALERT_DIGEST_RMA
                size: 4
                isdigest: false
                iszer: false
                ismubi: false
                iskeymgr_creator: false
                iskeymgr_owner: false
                inv_default: 0
                offset: 948
              }
              {
                name: OWNER_SW_CFG_ROM_WATCHDOG_BITE_THRESHOLD_CYCLES
                size: 4
                isdigest: false
                iszer: false
                ismubi: false
                iskeymgr_creator: false
                iskeymgr_owner: false
                inv_default: 0
                offset: 952
              }
              {
                name: OWNER_SW_CFG_ROM_KEYMGR_ROM_EXT_MEAS_EN
                size: 4
                isdigest: false
                iszer: false
                ismubi: false
                iskeymgr_creator: false
                iskeymgr_owner: false
                inv_default: 0
                offset: 956
              }
              {
                name: OWNER_SW_CFG_MANUF_STATE
                size: 4
                isdigest: false
                iszer: false
                ismubi: false
                iskeymgr_creator: false
                iskeymgr_owner: false
                inv_default: 0
                offset: 960
              }
              {
                name: OWNER_SW_CFG_ROM_RSTMGR_INFO_EN
                size: 4
                isdigest: false
                iszer: false
                ismubi: false
                iskeymgr_creator: false
                iskeymgr_owner: false
                inv_default: 0
                offset: 964
              }
              {
                name: OWNER_SW_CFG_DIGEST
                size: 8
                offset: 968
                ismubi: false
                isdigest: true
                iszer: false
                inv_default: 4123931682964426286
                iskeymgr_creator: false
                iskeymgr_owner: false
              }
            ]
            desc:
              '''
              Software configuration partition.
              This contains data that changes software behavior in the ROM, for
              example enabling defensive features in ROM or selecting failure
              modes if verification fails.
              '''
            iskeymgr_creator: false
            iskeymgr_owner: false
            ignore_read_lock_in_rma: false
            size: 600
            offset: 376
          }
          {
            name: AUTH_SLOT_STATE
            variant: Unbuffered
            absorb: false
            secret: false
            sw_digest: false
            hw_digest: false
            write_lock: None
            read_lock: CSR
            key_sel: NoKey
            integrity: true
            bkout_type: false
            zeroizable: false
            items:
            [
              {
                name: AUTH_SLOT_STATE_ROT_FIRMWARE
                size: 16
                desc:
                  '''
                  RoT Firmware Auth Slot State
                  SLOT_ST_RAW:       slot not yet claimed (factory default)
                  SLOT_ST_LOCKED0:   first slot claimed
                  SLOT_ST_RELEASED0: first slot released (assets have been cleared, ready to xfer)
                  SLOT_ST_LOCKED1:   second slot claimed
                  SLOT_ST_RELEASED1: second slot released (assets have been cleared, ready to xfer)
                  SLOT_ST_LOCKED2:   third slot claimed
                  SLOT_ST_RELEASED2: third slot released (assets have been cleared, ready to xfer)
                  SLOT_ST_LOCKED3:   fourth slot claimed
                  SLOT_ST_SCRAPPED:  scrap state - terminal
                  '''
                isdigest: false
                iszer: false
                ismubi: false
                iskeymgr_creator: false
                iskeymgr_owner: false
                inv_default: 0
                offset: 976
              }
              {
                name: AUTH_SLOT_STATE_SOC_FIRMWARE
                size: 16
                desc:
                  '''
                  SoC Firmware Key Slot State
                  SLOT_ST_RAW:       slot not yet claimed (factory default)
                  SLOT_ST_LOCKED0:   first slot claimed
                  SLOT_ST_RELEASED0: first slot released (assets have been cleared, ready to xfer)
                  SLOT_ST_LOCKED1:   second slot claimed
                  SLOT_ST_RELEASED1: second slot released (assets have been cleared, ready to xfer)
                  SLOT_ST_LOCKED2:   third slot claimed
                  SLOT_ST_RELEASED2: third slot released (assets have been cleared, ready to xfer)
                  SLOT_ST_LOCKED3:   fourth slot claimed
                  SLOT_ST_SCRAPPED:  scrap state - terminal
                  '''
                isdigest: false
                iszer: false
                ismubi: false
                iskeymgr_creator: false
                iskeymgr_owner: false
                inv_default: 0
                offset: 992
              }
            ]
            desc:
              '''
              SW managed authentication slot states partition.

              Multibit enable value for the tracking the authentication slot states.
              Note that the states can be written multiple times in a device lifetime.
              The values to be written are engineered in the same way as the LC_CTRL
              state encoding words so that the ECC encoding remains valid even after
              updating the values.

              The constants can be found in the lc_ctrl_state_pkg.sv package.

              The programming order has to adhere to:

              SLOT_ST_RAW (factory all-zero state) ->
              SLOT_ST_LOCKED0 ->
              SLOT_ST_RELEASED0 ->
              ...
              SLOT_ST_SCRAPPED

              Note that if there are less than 4 slots available the higher slot states
              become logically equivalent to SLOT_ST_SCRAPPED (firmware has to handle
              this correctly).
              '''
            iskeymgr_creator: false
            iskeymgr_owner: false
            ignore_read_lock_in_rma: false
            size: 32
            offset: 976
          }
          {
            name: ROT_CREATOR_AUTH
            variant: Unbuffered
            absorb: false
            secret: false
            sw_digest: true
            hw_digest: false
            write_lock: Digest
            read_lock: CSR
            key_sel: NoKey
            integrity: true
            bkout_type: false
            zeroizable: false
            items:
            [
              {
                name: ROT_CREATOR_AUTH_NON_RAW_MFW_CODESIGN_KEY
                size: 160
                desc:
                  '''
                  Pub Key used to verify the manufacturing provisioning Software container
                  160B = Custom Cert --> {PubKey:48, Signature:48, Device ID:32, metadata:16}
                  It is expected to be provisioned at Chip Probe stage when LC = TEST
                  i.e. provisioning protected under proper lifecycle logistics / secure supplychain management
                  '''
                isdigest: false
                iszer: false
                ismubi: false
                iskeymgr_creator: false
                iskeymgr_owner: false
                inv_default: 0
                offset: 1008
              }
              {
                name: ROT_CREATOR_AUTH_OWNERSHIP_STATE
                size: 4
                desc:
                  '''
                  Creator Ownership transfer state management
                  UNLOCKED - ownership of ROT not yet claimed
                  LOCKED   - ownership claimed and
                  RELEASED - Release ownership (assets have been cleared, ready to xfer)
                  '''
                isdigest: false
                iszer: false
                ismubi: false
                iskeymgr_creator: false
                iskeymgr_owner: false
                inv_default: 0
                offset: 1168
              }
              {
                name: ROT_CREATOR_AUTH_ROM2_PATCH_SIGVERIFY_KEY
                size: 160
                desc:
                  '''
                  Pub Key used to verify the ROM2 OTP based patch
                  160B = Custom Cert --> {PubKey:48, Signature:48, Device ID:32, metadata:16}
                  It is expected to be provisioned at Chip Probe stage when LC = TEST
                  i.e. provisioning protected under proper lifecycle logistics / secure supplychain management
                    OTP based key (instead of ROM) facilitates easy key rotation
                  '''
                isdigest: false
                iszer: false
                ismubi: false
                iskeymgr_creator: false
                iskeymgr_owner: false
                inv_default: 0
                offset: 1172
              }
              {
                name: ROT_CREATOR_AUTH_KEYMANIFEST_KEY
                size: 160
                desc:
                  '''
                  Pub Key used to verify the ROT CREATOR KEY MANIFEST.
                  KM is used to provisioning additional keys in (external) flash
                  160B = Custom Cert --> {PubKey:48, Signature:48, Device ID:32, metadata:16}
                  It is expected to be provisioned at Chip Probe stage when LC = TEST
                  i.e. provisioning protected under proper lifecycle logistics / secure supplychain management
                  '''
                isdigest: false
                iszer: false
                ismubi: false
                iskeymgr_creator: false
                iskeymgr_owner: false
                inv_default: 0
                offset: 1332
              }
              {
                name: ROT_CREATOR_AUTH_UNLOCK4XFER_KEY
                size: 160
                desc:
                  '''
                  Pub Key used to verify the ROT CREATOR KEY MANIFEST.
                  Used to authenticate the Unlock Ownership payload. Key Type: ECC NIST-P384 Curve.
                  160B = Custom Cert --> {PubKey:48, Signature:48, Device ID:32, metadata:16}
                  Can be made part bound i.e. unique per part key cert
                  i.e. provisioning protected under proper lifecycle logistics / secure supplychain management
                  '''
                isdigest: false
                iszer: false
                ismubi: false
                iskeymgr_creator: false
                iskeymgr_owner: false
                inv_default: 0
                offset: 1492
              }
              {
                name: ROT_CREATOR_AUTH_IDENTITY_CERT
                size: 768
                desc: ROT Device Identity Certificate endorsed by Silicon Creator stable off device PKI
                isdigest: false
                iszer: false
                ismubi: false
                iskeymgr_creator: false
                iskeymgr_owner: false
                inv_default: 0
                offset: 1652
              }
              {
                name: ROT_CREATOR_AUTH_DIGEST
                size: 8
                offset: 2424
                ismubi: false
                isdigest: true
                iszer: false
                inv_default: 15819321713790451465
                iskeymgr_creator: false
                iskeymgr_owner: false
              }
            ]
            desc: Software managed creator partition.
            iskeymgr_creator: false
            iskeymgr_owner: false
            ignore_read_lock_in_rma: false
            size: 1424
            offset: 1008
          }
          {
            name: ROT_FIRMWARE_AUTH_SLOT0
            variant: Unbuffered
            absorb: false
            secret: false
            sw_digest: true
            hw_digest: false
            write_lock: Digest
            read_lock: CSR
            key_sel: NoKey
            integrity: true
            bkout_type: false
            zeroizable: false
            items:
            [
              {
                name: ROT_FIRMWARE_AUTH_SLOT0_HASH
                size: 128
                desc: Hash of public key for RoT firmware (slot 0)
                isdigest: false
                iszer: false
                ismubi: false
                iskeymgr_creator: false
                iskeymgr_owner: false
                inv_default: 0
                offset: 2432
              }
              {
                name: ROT_FIRMWARE_AUTH_SLOT0_DIGEST
                size: 8
                offset: 2560
                ismubi: false
                isdigest: true
                iszer: false
                inv_default: 4036071169128675423
                iskeymgr_creator: false
                iskeymgr_owner: false
              }
            ]
            desc: Software managed RoT firmware authentication slot
            iskeymgr_creator: false
            iskeymgr_owner: false
            ignore_read_lock_in_rma: false
            size: 136
            offset: 2432
          }
          {
            name: ROT_FIRMWARE_AUTH_SLOT1
            variant: Unbuffered
            absorb: false
            secret: false
            sw_digest: true
            hw_digest: false
            write_lock: Digest
            read_lock: CSR
            key_sel: NoKey
            integrity: true
            bkout_type: false
            zeroizable: false
            items:
            [
              {
                name: ROT_FIRMWARE_AUTH_SLOT1_HASH
                size: 128
                desc: Hash of public key for RoT firmware (slot 1)
                isdigest: false
                iszer: false
                ismubi: false
                iskeymgr_creator: false
                iskeymgr_owner: false
                inv_default: 0
                offset: 2568
              }
              {
                name: ROT_FIRMWARE_AUTH_SLOT1_DIGEST
                size: 8
                offset: 2696
                ismubi: false
                isdigest: true
                iszer: false
                inv_default: 5650730686695884436
                iskeymgr_creator: false
                iskeymgr_owner: false
              }
            ]
            desc: Software managed RoT firmware authentication slot
            iskeymgr_creator: false
            iskeymgr_owner: false
            ignore_read_lock_in_rma: false
            size: 136
            offset: 2568
          }
          {
            name: ROT_FIRMWARE_AUTH_SLOT2
            variant: Unbuffered
            absorb: false
            secret: false
            sw_digest: true
            hw_digest: false
            write_lock: Digest
            read_lock: CSR
            key_sel: NoKey
            integrity: true
            bkout_type: false
            zeroizable: false
            items:
            [
              {
                name: ROT_FIRMWARE_AUTH_SLOT2_HASH
                size: 128
                desc: Hash of public key for RoT firmware (slot 2)
                isdigest: false
                iszer: false
                ismubi: false
                iskeymgr_creator: false
                iskeymgr_owner: false
                inv_default: 0
                offset: 2704
              }
              {
                name: ROT_FIRMWARE_AUTH_SLOT2_DIGEST
                size: 8
                offset: 2832
                ismubi: false
                isdigest: true
                iszer: false
                inv_default: 10448767896760702259
                iskeymgr_creator: false
                iskeymgr_owner: false
              }
            ]
            desc: Software managed RoT firmware authentication slot
            iskeymgr_creator: false
            iskeymgr_owner: false
            ignore_read_lock_in_rma: false
            size: 136
            offset: 2704
          }
          {
            name: ROT_FIRMWARE_AUTH_SLOT3
            variant: Unbuffered
            absorb: false
            secret: false
            sw_digest: true
            hw_digest: false
            write_lock: Digest
            read_lock: CSR
            key_sel: NoKey
            integrity: true
            bkout_type: false
            zeroizable: false
            items:
            [
              {
                name: ROT_FIRMWARE_AUTH_SLOT3_HASH
                size: 128
                desc: Hash of public key for RoT firmware (slot 3)
                isdigest: false
                iszer: false
                ismubi: false
                iskeymgr_creator: false
                iskeymgr_owner: false
                inv_default: 0
                offset: 2840
              }
              {
                name: ROT_FIRMWARE_AUTH_SLOT3_DIGEST
                size: 8
                offset: 2968
                ismubi: false
                isdigest: true
                iszer: false
                inv_default: 4275689744169575455
                iskeymgr_creator: false
                iskeymgr_owner: false
              }
            ]
            desc: Software managed RoT firmware authentication slot
            iskeymgr_creator: false
            iskeymgr_owner: false
            ignore_read_lock_in_rma: false
            size: 136
            offset: 2840
          }
          {
            name: SOC_FIRMWARE_AUTH_SLOT0
            variant: Unbuffered
            absorb: false
            secret: false
            sw_digest: true
            hw_digest: false
            write_lock: Digest
            read_lock: CSR
            key_sel: NoKey
            integrity: true
            bkout_type: false
            zeroizable: false
            items:
            [
              {
                name: SOC_FIRMWARE_AUTH_SLOT0_HASH
                size: 128
                desc: Hash of public key for SoC firmware (slot 0)
                isdigest: false
                iszer: false
                ismubi: false
                iskeymgr_creator: false
                iskeymgr_owner: false
                inv_default: 0
                offset: 2976
              }
              {
                name: SOC_FIRMWARE_AUTH_SLOT0_DIGEST
                size: 8
                offset: 3104
                ismubi: false
                isdigest: true
                iszer: false
                inv_default: 6297967080745773217
                iskeymgr_creator: false
                iskeymgr_owner: false
              }
            ]
            desc: Software managed SoC firmware authentication slot
            iskeymgr_creator: false
            iskeymgr_owner: false
            ignore_read_lock_in_rma: false
            size: 136
            offset: 2976
          }
          {
            name: SOC_FIRMWARE_AUTH_SLOT1
            variant: Unbuffered
            absorb: false
            secret: false
            sw_digest: true
            hw_digest: false
            write_lock: Digest
            read_lock: CSR
            key_sel: NoKey
            integrity: true
            bkout_type: false
            zeroizable: false
            items:
            [
              {
                name: SOC_FIRMWARE_AUTH_SLOT1_HASH
                size: 128
                desc: Hash of public key for SoC firmware (slot 1)
                isdigest: false
                iszer: false
                ismubi: false
                iskeymgr_creator: false
                iskeymgr_owner: false
                inv_default: 0
                offset: 3112
              }
              {
                name: SOC_FIRMWARE_AUTH_SLOT1_DIGEST
                size: 8
                offset: 3240
                ismubi: false
                isdigest: true
                iszer: false
                inv_default: 7544202290022723701
                iskeymgr_creator: false
                iskeymgr_owner: false
              }
            ]
            desc: Software managed SoC firmware authentication slot
            iskeymgr_creator: false
            iskeymgr_owner: false
            ignore_read_lock_in_rma: false
            size: 136
            offset: 3112
          }
          {
            name: SOC_FIRMWARE_AUTH_SLOT2
            variant: Unbuffered
            absorb: false
            secret: false
            sw_digest: true
            hw_digest: false
            write_lock: Digest
            read_lock: CSR
            key_sel: NoKey
            integrity: true
            bkout_type: false
            zeroizable: false
            items:
            [
              {
                name: SOC_FIRMWARE_AUTH_SLOT2_HASH
                size: 128
                desc: Hash of public key for SoC firmware (slot 2)
                isdigest: false
                iszer: false
                ismubi: false
                iskeymgr_creator: false
                iskeymgr_owner: false
                inv_default: 0
                offset: 3248
              }
              {
                name: SOC_FIRMWARE_AUTH_SLOT2_DIGEST
                size: 8
                offset: 3376
                ismubi: false
                isdigest: true
                iszer: false
                inv_default: 14656815325044117528
                iskeymgr_creator: false
                iskeymgr_owner: false
              }
            ]
            desc: Software managed SoC firmware authentication slot
            iskeymgr_creator: false
            iskeymgr_owner: false
            ignore_read_lock_in_rma: false
            size: 136
            offset: 3248
          }
          {
            name: SOC_FIRMWARE_AUTH_SLOT3
            variant: Unbuffered
            absorb: false
            secret: false
            sw_digest: true
            hw_digest: false
            write_lock: Digest
            read_lock: CSR
            key_sel: NoKey
            integrity: true
            bkout_type: false
            zeroizable: false
            items:
            [
              {
                name: SOC_FIRMWARE_AUTH_SLOT3_HASH
                size: 128
                desc: Hash of public key for SoC firmware (slot 3)
                isdigest: false
                iszer: false
                ismubi: false
                iskeymgr_creator: false
                iskeymgr_owner: false
                inv_default: 0
                offset: 3384
              }
              {
                name: SOC_FIRMWARE_AUTH_SLOT3_DIGEST
                size: 8
                offset: 3512
                ismubi: false
                isdigest: true
                iszer: false
                inv_default: 16898073465963608763
                iskeymgr_creator: false
                iskeymgr_owner: false
              }
            ]
            desc: Software managed SoC firmware authentication slot
            iskeymgr_creator: false
            iskeymgr_owner: false
            ignore_read_lock_in_rma: false
            size: 136
            offset: 3384
          }
          {
            name: EXT_NVM
            variant: Unbuffered
            absorb: false
            secret: false
            sw_digest: false
            hw_digest: false
            write_lock: None
            read_lock: CSR
            key_sel: NoKey
            integrity: false
            bkout_type: false
            zeroizable: false
            items:
            [
              {
                name: EXT_NVM_ANTIREPLAY_FRESHNESS_CNT
                size: 1024
                desc:
                  '''
                  Fully SW managed partition
                  1 bit (double bit allocated for redundancy - i.e. 2 physical bits for every logical bit) per day
                  assuming 10 year product lifecycle, allocating 8192 bits of freshness protection.
                  Implemented as thermometer encoding. Redundant bit programming & logical OR-ing managed by
                  software. Cannot be ECC protected since different bits in a fuse row are programmed at different times.
                  '''
                isdigest: false
                iszer: false
                ismubi: false
                iskeymgr_creator: false
                iskeymgr_owner: false
                inv_default: 0
                offset: 3520
              }
            ]
            desc: Anti-replay protection Strike Counters partition.
            iskeymgr_creator: false
            iskeymgr_owner: false
            ignore_read_lock_in_rma: false
            size: 1024
            offset: 3520
          }
          {
            name: HW_CFG0
            variant: Buffered
            secret: false
            sw_digest: false
            hw_digest: true
            write_lock: Digest
            read_lock: None
            key_sel: NoKey
            integrity: true
            bkout_type: true
            zeroizable: false
            skip_sw_header: true
            items:
            [
              {
                name: DEVICE_ID
                size: 32
                inv_default: 84636775181865843423447751136542243067225345129144998513113609321933118751675
                isdigest: false
                iszer: false
                ismubi: false
                iskeymgr_creator: false
                iskeymgr_owner: false
                offset: 4544
              }
              {
                name: MANUF_STATE
                size: 32
                inv_default: 89960518397345998442210387957448911146016937697982416014732294109643662651482
                isdigest: false
                iszer: false
                ismubi: false
                iskeymgr_creator: false
                iskeymgr_owner: false
                offset: 4576
              }
              {
                name: HW_CFG0_DIGEST
                size: 8
                offset: 4608
                ismubi: false
                isdigest: true
                iszer: false
                inv_default: 8821601860276922949
                iskeymgr_creator: false
                iskeymgr_owner: false
              }
            ]
            desc:
              '''
              Hardware configuration 0 partition.
              This contains
              - DEVICE_ID: Unique device identifier.
              - MANUF_STATE: Vector for capturing the manufacturing status.
              '''
            absorb: false
            iskeymgr_creator: false
            iskeymgr_owner: false
            ignore_read_lock_in_rma: false
            size: 72
            offset: 4544
          }
          {
            name: HW_CFG1
            variant: Buffered
            secret: false
            sw_digest: false
            hw_digest: true
            write_lock: Digest
            read_lock: None
            key_sel: NoKey
            integrity: true
            bkout_type: true
            zeroizable: false
            skip_sw_header: true
            items:
            [
              {
                name: SEC_BOOT_DBG
                size: 4
                inv_default: 0
                desc:
                  '''
                  Multibit enable value for Secure Boot.
                  Encoding TBD
                  '''
                isdigest: false
                iszer: false
                ismubi: false
                iskeymgr_creator: false
                iskeymgr_owner: false
                offset: 4616
              }
              {
                name: EN_CSRNG_SW_APP_READ
                size: 1
                ismubi: true
                inv_default: 105
                desc:
                  '''
                  Enablement of CSRNG software application interface. A
                  kMultiBitBool8True value enables, while all other values
                  disable. Enablement is required to extract output from
                  CSRNG via software.
                  '''
                isdigest: false
                iszer: false
                iskeymgr_creator: false
                iskeymgr_owner: false
                offset: 4620
              }
              {
                name: EN_SRAM_IFETCH
                size: 1
                ismubi: true
                inv_default: 105
                isdigest: false
                iszer: false
                iskeymgr_creator: false
                iskeymgr_owner: false
                offset: 4621
              }
              {
                name: HW_CFG1_DIGEST
                size: 8
                offset: 4624
                ismubi: false
                isdigest: true
                iszer: false
                inv_default: 9673330360152269864
                iskeymgr_creator: false
                iskeymgr_owner: false
              }
            ]
            desc:
              '''
              Hardware configuration 1 partition.
              This contains
              EN_SRAM_IFETCH: Enable / disable execute from SRAM CSR switch.
              SOC_DBG_STATE: Multibit enable value for the SOC debug authorization.
              Note SOC_DBG_STATE will be written twice in a device lifetime. The
              values to be written are engineered in the same way as the LC_CTRL
              state encoding words: the ECC encoding remains valid even after
              writing the second value on top of the first.

              The constants can be found in the lc_ctrl_state_pkg.sv package.

              The programming order has to adhere to:

              SOC_DBG_RAW -> SOC_DBG_PRE_PROD -> SOC_DBG_PROD.
              '''
            absorb: false
            iskeymgr_creator: false
            iskeymgr_owner: false
            ignore_read_lock_in_rma: false
            size: 16
            offset: 4616
          }
          {
            name: SECRET0
            variant: Buffered
            secret: true
            sw_digest: false
            hw_digest: true
            write_lock: Digest
            read_lock: Digest
            ignore_read_lock_in_rma: true
            key_sel: Secret0Key
            integrity: true
            bkout_type: false
            zeroizable: true
            skip_sw_header: true
            items:
            [
              {
                name: TEST_UNLOCK_TOKEN
                inv_default: 191985393975828609903709283012653827085
                size: 16
                isdigest: false
                iszer: false
                ismubi: false
                iskeymgr_creator: false
                iskeymgr_owner: false
                offset: 4632
              }
              {
                name: TEST_EXIT_TOKEN
                inv_default: 8049454917427216925997827152549284667
                size: 16
                isdigest: false
                iszer: false
                ismubi: false
                iskeymgr_creator: false
                iskeymgr_owner: false
                offset: 4648
              }
              {
                name: SECRET0_DIGEST
                size: 8
                offset: 4664
                ismubi: false
                isdigest: true
                iszer: false
                inv_default: 10065874593229139721
                iskeymgr_creator: false
                iskeymgr_owner: false
              }
              {
                name: SECRET0_ZER
                size: 8
                offset: 4672
                ismubi: false
                isdigest: false
                iszer: true
                inv_default: 0
                iskeymgr_creator: false
                iskeymgr_owner: false
              }
            ]
            desc:
              '''
              Secret partition 0.
              This contains TEST lifecycle unlock tokens.
              '''
            absorb: false
            iskeymgr_creator: false
            iskeymgr_owner: false
            size: 48
            offset: 4632
          }
          {
            name: SECRET1
            variant: Buffered
            secret: true
            sw_digest: false
            hw_digest: true
            write_lock: Digest
            read_lock: Digest
            ignore_read_lock_in_rma: true
            key_sel: Secret1Key
            integrity: true
            bkout_type: false
            zeroizable: true
            skip_sw_header: true
            items:
            [
              {
                name: SRAM_DATA_KEY_SEED
                inv_default: 119626835793529483393158377097849370351
                size: 16
                isdigest: false
                iszer: false
                ismubi: false
                iskeymgr_creator: false
                iskeymgr_owner: false
                offset: 4680
              }
              {
                name: SECRET1_DIGEST
                size: 8
                offset: 4696
                ismubi: false
                isdigest: true
                iszer: false
                inv_default: 12446391818523284464
                iskeymgr_creator: false
                iskeymgr_owner: false
              }
              {
                name: SECRET1_ZER
                size: 8
                offset: 4704
                ismubi: false
                isdigest: false
                iszer: true
                inv_default: 0
                iskeymgr_creator: false
                iskeymgr_owner: false
              }
            ]
            desc:
              '''
              Secret partition 1.
              This contains the SRAM scrambling key seed.
              '''
            absorb: false
            iskeymgr_creator: false
            iskeymgr_owner: false
            size: 32
            offset: 4680
          }
          {
            name: SECRET2
            variant: Buffered
            secret: true
            sw_digest: false
            hw_digest: true
            write_lock: Digest
            read_lock: Digest
            ignore_read_lock_in_rma: true
            key_sel: Secret2Key
            integrity: true
            bkout_type: false
            zeroizable: true
            skip_sw_header: true
            items:
            [
              {
                name: RMA_TOKEN
                inv_default: 257151471457813701810792034009910885873
                size: 16
                isdigest: false
                iszer: false
                ismubi: false
                iskeymgr_creator: false
                iskeymgr_owner: false
                offset: 4712
              }
              {
                name: CREATOR_ROOT_KEY_SHARE0
                inv_default: 58428367318477997995158430436185008200278041856729653820014384131744449381794
                size: 32
                iskeymgr_creator: true
                isdigest: false
                iszer: false
                ismubi: false
                iskeymgr_owner: false
                offset: 4728
              }
              {
                name: CREATOR_ROOT_KEY_SHARE1
                inv_default: 81109909720667310531206694470923378649726943238131960830210841988782597012480
                size: 32
                iskeymgr_creator: true
                isdigest: false
                iszer: false
                ismubi: false
                iskeymgr_owner: false
                offset: 4760
              }
              {
                name: CREATOR_SEED
                inv_default: 63999019030607151289909366880942569362330468042440373196189507388017079630937
                size: 32
                iskeymgr_creator: true
                isdigest: false
                iszer: false
                ismubi: false
                iskeymgr_owner: false
                offset: 4792
              }
              {
                name: SECRET2_DIGEST
                size: 8
                offset: 4824
                ismubi: false
                isdigest: true
                iszer: false
                inv_default: 16862586926326724172
                iskeymgr_creator: false
                iskeymgr_owner: false
              }
              {
                name: SECRET2_ZER
                size: 8
                offset: 4832
                ismubi: false
                isdigest: false
                iszer: true
                inv_default: 0
                iskeymgr_creator: false
                iskeymgr_owner: false
              }
            ]
            desc:
              '''
              Secret partition 2.
              This contains RMA unlock token, creator root key, and creator seed.
              '''
            absorb: false
            iskeymgr_creator: true
            iskeymgr_owner: false
            size: 128
            offset: 4712
          }
          {
            name: SECRET3
            variant: Buffered
            secret: true
            sw_digest: false
            hw_digest: true
            write_lock: Digest
            read_lock: Digest
            key_sel: Secret3Key
            integrity: true
            bkout_type: false
            zeroizable: true
            skip_sw_header: true
            items:
            [
              {
                name: OWNER_SEED
                inv_default: 10206999105613237488305124545664851698610302080045852370886952986780297145526
                size: 32
                iskeymgr_owner: true
                isdigest: false
                iszer: false
                ismubi: false
                iskeymgr_creator: false
                offset: 4840
              }
              {
                name: SECRET3_DIGEST
                size: 8
                offset: 4872
                ismubi: false
                isdigest: true
                iszer: false
                inv_default: 10297274993151818246
                iskeymgr_creator: false
                iskeymgr_owner: false
              }
              {
                name: SECRET3_ZER
                size: 8
                offset: 4880
                ismubi: false
                isdigest: false
                iszer: true
                inv_default: 0
                iskeymgr_creator: false
                iskeymgr_owner: false
              }
            ]
            desc:
              '''
              Secret partition 3.
              This contains the owner seed.
              '''
            absorb: false
            iskeymgr_creator: false
            iskeymgr_owner: true
            ignore_read_lock_in_rma: false
            size: 48
            offset: 4840
          }
          {
            name: LIFE_CYCLE
            variant: LifeCycle
            secret: false
            sw_digest: false
            hw_digest: false
            write_lock: None
            read_lock: None
            key_sel: NoKey
            integrity: true
            bkout_type: false
            skip_sw_header: true
            items:
            [
              {
                name: LC_TRANSITION_CNT
                inv_default: 34765581757057702526568169959179506991796799849684129792408382543682161064351438550357191642801906499564079722040959
                size: 48
                isdigest: false
                iszer: false
                ismubi: false
                iskeymgr_creator: false
                iskeymgr_owner: false
                offset: 4888
              }
              {
                name: LC_STATE
                inv_default: 508406651299787982309904825443985373106236637081727939090585644961445206666689630393817246511712
                size: 40
                isdigest: false
                iszer: false
                ismubi: false
                iskeymgr_creator: false
                iskeymgr_owner: false
                offset: 4936
              }
            ]
            desc:
              '''
              Lifecycle partition.
              This contains lifecycle transition count and state. This partition
              cannot be locked since the life cycle state needs to advance to RMA
              in-field. Note that while this partition is not marked secret, it
              is not readable nor writeable via the DAI. Only the LC controller
              can access this partition, and even via the LC controller it is not
              possible to read the raw manufacturing life cycle state in encoded
              form, since that encoding is considered a netlist secret. The LC
              controller only exposes a decoded version of this state.
              '''
            absorb: false
            iskeymgr_creator: false
            iskeymgr_owner: false
            zeroizable: false
            ignore_read_lock_in_rma: false
            size: 88
            offset: 4888
          }
        ]
      }
    }
    {
      name: lc_ctrl
      type: lc_ctrl
      base_addrs:
      {
        regs:
        {
          hart: 0x30150000
        }
        dmi:
        {
          soc_dbg: 0x3000
        }
      }
      memory: {}
      param_list:
      [
        {
          name: RndCnstLcKeymgrDivInvalid
          desc: Diversification value used for all invalid life cycle states.
          type: lc_ctrl_pkg::lc_keymgr_div_t
          randcount: 128
          randtype: data
          name_top: RndCnstLcCtrlLcKeymgrDivInvalid
          default: 0xbf0c3f8670e567e3d45248fcc97c0789
          randwidth: 128
        }
        {
          name: RndCnstLcKeymgrDivTestUnlocked
          desc: Diversification value used for the TEST_UNLOCKED* life cycle states.
          type: lc_ctrl_pkg::lc_keymgr_div_t
          randcount: 128
          randtype: data
          name_top: RndCnstLcCtrlLcKeymgrDivTestUnlocked
          default: 0x1cc43863aa87fa680492a054b140bd9
          randwidth: 128
        }
        {
          name: RndCnstLcKeymgrDivDev
          desc: Diversification value used for the DEV life cycle state.
          type: lc_ctrl_pkg::lc_keymgr_div_t
          randcount: 128
          randtype: data
          name_top: RndCnstLcCtrlLcKeymgrDivDev
          default: 0xe143dfc4b6dbeed1bf90abfb15626596
          randwidth: 128
        }
        {
          name: RndCnstLcKeymgrDivProduction
          desc: Diversification value used for the PROD/PROD_END life cycle states.
          type: lc_ctrl_pkg::lc_keymgr_div_t
          randcount: 128
          randtype: data
          name_top: RndCnstLcCtrlLcKeymgrDivProduction
          default: 0xd2efd423c911abc24e67161254169bdb
          randwidth: 128
        }
        {
          name: RndCnstLcKeymgrDivRma
          desc: Diversification value used for the RMA life cycle state.
          type: lc_ctrl_pkg::lc_keymgr_div_t
          randcount: 128
          randtype: data
          name_top: RndCnstLcCtrlLcKeymgrDivRma
          default: 0x5c2840f0d87b7f933be73a25096f4a87
          randwidth: 128
        }
        {
          name: RndCnstInvalidTokens
          desc: Compile-time random bits used for invalid tokens in the token mux
          type: lc_ctrl_pkg::lc_token_mux_t
          randcount: 1024
          randtype: data
          name_top: RndCnstLcCtrlInvalidTokens
          default: 0xddc34ec65f281d26d8cf913a1d6eefb27a1a456b36c86f2e9c6300811caf885fe8b32371241d3a38df9077469a0cab69ac24eebab82afe4759cfc663225c12d7753aa2ee916025df0be5c28f4b20200e6920ce35374ace64e4cd2159e36d6b671c5a316a042d0dff88a19559e90e7c3956634c78db0f9c866205c5db2fd08403
          randwidth: 1024
        }
      ]
    }
    {
      name: aes
      type: aes
      base_addrs:
      {
        null:
        {
          hart: 0x21100000
        }
      }
      memory: {}
      param_list:
      [
        {
          name: RndCnstClearingLfsrSeed
          desc: Default seed of the PRNG used for register clearing.
          type: aes_pkg::clearing_lfsr_seed_t
          randcount: 64
          randtype: data
          name_top: RndCnstAesClearingLfsrSeed
          default: 0x3e2045fe16f058e
          randwidth: 64
        }
        {
          name: RndCnstClearingLfsrPerm
          desc: Permutation applied to the LFSR of the PRNG used for clearing.
          type: aes_pkg::clearing_lfsr_perm_t
          randcount: 64
          randtype: perm
          name_top: RndCnstAesClearingLfsrPerm
          default: 0x895f66b3a524a583ad3194f4050ba70fe17684f82f472ade7426bbcd7f04e78188fc91dfdcb28d8c0a12ab1d56c1c6e5
          randwidth: 384
        }
        {
          name: RndCnstClearingSharePerm
          desc: Permutation applied to the clearing PRNG output for clearing the second share of registers.
          type: aes_pkg::clearing_lfsr_perm_t
          randcount: 64
          randtype: perm
          name_top: RndCnstAesClearingSharePerm
          default: 0xf23c5c33b6c284bfaa154b401dd5b5c3fb1f979cf8462428a43904caedfa7979b420f48d24a0599fdad8d866a0bd5393
          randwidth: 384
        }
        {
          name: RndCnstMaskingLfsrSeed
          desc: Default seed of the PRNG used for masking.
          type: aes_pkg::masking_lfsr_seed_t
          randcount: 288
          randtype: data
          name_top: RndCnstAesMaskingLfsrSeed
          default: 0x3c86671d455619980f4674ca14d88ebb455250f4e07680d8246d7de5057efc5b212368d0
          randwidth: 288
        }
        {
          name: RndCnstMaskingLfsrPerm
          desc: Permutation applied to the output of the PRNG used for masking.
          type: aes_pkg::masking_lfsr_perm_t
          randcount: 160
          randtype: perm
          name_top: RndCnstAesMaskingLfsrPerm
          default: 0x2e4841094f5a349e08352f33968e647678603a49666c7775614d8f6e15186b4047289d6f210130553e700331450d221a136d4c591c575d17252c949f1f2b2a837e3946950597678b040e36632980069a374223626812110b9091275c853d071b567f8c0a3b320c435e8d934e65828a86163c2d927a4b51025452798488989b1d107c3800815099203f0f725f73447114196a245b4a877b749c89691e5358267d
          randwidth: 1280
        }
      ]
    }
    {
      name: kmac
      type: kmac
      base_addrs:
      {
        null:
        {
          hart: 0x21120000
        }
      }
      memory: {}
      param_list:
      [
        {
          name: RndCnstLfsrSeed
          desc: Compile-time random data for PRNG default seed
          type: kmac_pkg::lfsr_seed_t
          randcount: 288
          randtype: data
          name_top: RndCnstKmacLfsrSeed
          default: 0x6c0daf4e52301cd75eaaf2c4ea2a366491a412af3e75b4511771a607249592fc2952d333
          randwidth: 288
        }
        {
          name: RndCnstLfsrPerm
          desc: Compile-time random permutation for PRNG output
          type: kmac_pkg::lfsr_perm_t
          randcount: 800
          randtype: perm
          name_top: RndCnstKmacLfsrPerm
          default: 0x991c59a42380599a891655a5352d82985be7d649a35d936c772d04956dd820926876e13ec296ca3f14d970600534683626374d4d681b01956f0bb8a4ab5105e958aeb0a251f239e7f6dcdd60db418aa30b55c628378808874c4ab29f04691867490c0da06be945fe16b6a5c15b1fb70815900027e1c145374f262692b16c5d63b9b8116bd6425dc71cf00ec24b00e7d0f014aaa6c1eb68e4091198b1ab59bc271c7124222d23b1ab9c54018e6580b2a7d699689a0ecfea5c2137248b31fc9de1758c2283879492db796602a40d57ac762ce97f60336187659c2652ab54a6c3c4398220c405bc082880f88a2ee437a69b9a85fc6d28059e33798fa2c66a004d508a53395a534968f2ce5d12a92f0042ac59c5ec319069d9537452f80a42a3af54702f30ca8c5a6d878078e2cb51c6479e30011cd266b229ce599a469d069160ef9e6e6aa2196d6eb432b38f9ba340a33ae3998ed9952875885c88b0d3f53683de16782e4a42a37c0c8631742605c612049d3d3d4cda9236b22516987b8556d402fa4eed63e6271c8d5b7a1a3d2103dc619d51b1fb19c52b436a298b8653da41bdd778d4193200871ac0a79d59ae1f5f44b15dc16489e4957004ebc4b63a6cd38729a82fae07e46cbe4833a8d2bf8d9049782718d44cc5bc715436579e99c091c432f048c9d4382f6a9a4f69de6887114f923a4432ab9617ab0bb4c6ea863d174b06940a2ea8c7fd505c581a62cdba9ef9cd802c56a700e2300af155492ba6595a50ba401965324ba787a24a06a0a6111dbd1cc1c1f1532899a2e5c0a84abca01ae3161540742a05645aa56826e45e22625464d32fcf2ae2ddb064d13af26187f2debb304ad99c6ab88bd70e8697c2522c442ae0dafe14a59303cc435d96f1a29ab521bb3d7e8023496d1f42c412e55450c339f10533ca60b1110d6a75f1fa131319c2c3b922c65699add9f668e441ddcb62132a887b562b8ec74ac0cc5e41d638ca7882b8ce9d3f2f8960098267d43c0bb7c17ad9cb1404f0ea4c2369326c46630780c5bd2869c9eed27b56b1b5395a1c812063544915949d7b9ae3fef36b5db53cec5770cc1c422e104aa4f8b8c0f23e1240e5e100bcbf6ac5c93ac17066a4ac455f32487c6d8369147d4fcc46ed34949aa939ac6ac8c40aef89080c2122c2498b5d4e28aa582d57ba121c401f748c79b99b06c288aa112d6722cced6871e620264787a21ad05d55faf86025607042281d83876a81bf30f11d55448598bcd491ce85cc1ca4ab9519677930e5983f45cfa24ddf078155ed41512ff5216ea3d2b811e07e1a21bd919f8b643a2338dc71cec4c4ed14cc11009dd3846775ddebb5f65b2ec64c5b7f9fb6fec97dd450f1140f497c74c9308845283405226becd772685a288573a901d430
          randwidth: 8000
        }
        {
          name: RndCnstBufferLfsrSeed
          desc: Compile-time random data for PRNG buffer default seed
          type: kmac_pkg::buffer_lfsr_seed_t
          randcount: 800
          randtype: data
          name_top: RndCnstKmacBufferLfsrSeed
          default: 0xa84997009610065e87c3d7f6261d94698b9d8ef1f778309f11160fbfa7481bee6b55c5189f370c0a37fbacc9633925fd92158d6de07bccc89d3a03dcb3705e6edfc6182f4633934827f5c72a5a1df71b1249028135f95b3dcec35ddce040862d3995fcbe
          randwidth: 800
        }
        {
          name: RndCnstMsgPerm
          desc: Compile-time random permutation for LFSR Message output
          type: kmac_pkg::msg_perm_t
          randcount: 64
          randtype: perm
          name_top: RndCnstKmacMsgPerm
          default: 0x81c5a3be5ef1992e1dcc078d330dadba86a4e53f6b521fc9e9956ad4b0c8197d0fc9b12cdca9c21d089139ff81a5817c
          randwidth: 384
        }
      ]
    }
    {
      name: otbn
      type: otbn
      base_addrs:
      {
        null:
        {
          hart: 0x21130000
        }
      }
      memory: {}
      param_list:
      [
        {
          name: RndCnstUrndPrngSeed
          desc: Default seed of the PRNG used for URND.
          type: otbn_pkg::urnd_prng_seed_t
          randcount: 288
          randtype: data
          name_top: RndCnstOtbnUrndPrngSeed
          default: 0xfa73a216740d626bb001be503766c58410432fed05072901b78b2a4eaffbb5366556c422
          randwidth: 288
        }
        {
          name: RndCnstBnMacUrndPerm
          desc: Compile-time random permutation for URND permutation in BN MAC.
          type: otbn_pkg::bn_mac_urnd_perm_t
          randcount: 256
          randtype: perm
          name_top: RndCnstOtbnBnMacUrndPerm
          default: 0x1902c3379e844ead5ee34500f47e10fedee8c45ff548ae78aadccb82fb390fb5ee61cabb91182844be47a57d2cf9d84f6c7c602ec917737990eb0405a408bc498832d00a465c1d50f274fa42b026153ce2532be1f8a7560ec11fcf2192b10d70fcd3acb436d7c69b982d75222fd52996852469a0c813ffa2343ecc232a80938c1a1164c73d4aa97ff16b5a0c8fdf33f314a1cdf083e606017bd95d9c09865867f765cebf663b31a38d8b438aab893a716e38e407e5524d9ffd6881a6628eece7876f4b9759c5b677efc04076ddd6e9ba7a2741951c5bb73fc216b2b9bd259a55ea1eda352051edd472e06d120b94a854af1bb330039ddb996ad14c57f6b863d2
          randwidth: 2048
        }
        {
          name: RndCnstOtbnKey
          desc: Compile-time random reset value for IMem/DMem scrambling key.
          type: otp_ctrl_pkg::otbn_key_t
          randcount: 128
          randtype: data
          name_top: RndCnstOtbnOtbnKey
          default: 0xfdfc150c6156628c4aa2cea5dba9f318
          randwidth: 128
        }
        {
          name: RndCnstOtbnNonce
          desc: Compile-time random reset value for IMem/DMem scrambling nonce.
          type: otp_ctrl_pkg::otbn_nonce_t
          randcount: 64
          randtype: data
          name_top: RndCnstOtbnOtbnNonce
          default: 0xc48359728441317
          randwidth: 64
        }
      ]
    }
    {
      name: keymgr_dpe
      type: keymgr_dpe
      base_addrs:
      {
        null:
        {
          hart: 0x21140000
        }
      }
      memory: {}
      param_list:
      [
        {
          name: RndCnstLfsrSeed
          desc: Compile-time random bits for initial LFSR seed
          type: keymgr_pkg::lfsr_seed_t
          randcount: 64
          randtype: data
          name_top: RndCnstKeymgrDpeLfsrSeed
          default: 0xc074f52708cd3dcb
          randwidth: 64
        }
        {
          name: RndCnstLfsrPerm
          desc: Compile-time random permutation for LFSR output
          type: keymgr_pkg::lfsr_perm_t
          randcount: 64
          randtype: perm
          name_top: RndCnstKeymgrDpeLfsrPerm
          default: 0xa4dae633dd4b39bb798c461eddd6540562a8f31eecab89150859493d34971f27c8cee446d3f43a8a78408300daf9cdaf
          randwidth: 384
        }
        {
          name: RndCnstRandPerm
          desc: Compile-time random permutation for entropy used in share overriding
          type: keymgr_pkg::rand_perm_t
          randcount: 32
          randtype: perm
          name_top: RndCnstKeymgrDpeRandPerm
          default: 0xea7319e8af54906dd700a08e16c3cb73077b73e4
          randwidth: 160
        }
        {
          name: RndCnstRevisionSeed
          desc: Compile-time random bits for revision seed
          type: keymgr_pkg::seed_t
          randcount: 256
          randtype: data
          name_top: RndCnstKeymgrDpeRevisionSeed
          default: 0x67f1d20123ae962a003e30c2a8942f27c4ca21c6327fb8e7bf10c9ef8b9c0deb
          randwidth: 256
        }
        {
          name: RndCnstSoftOutputSeed
          desc: Compile-time random bits for software generation seed
          type: keymgr_pkg::seed_t
          randcount: 256
          randtype: data
          name_top: RndCnstKeymgrDpeSoftOutputSeed
          default: 0x2418423faff41e7b4ff4b0e69553d130a0407693de540219fc8494453ae7fd82
          randwidth: 256
        }
        {
          name: RndCnstHardOutputSeed
          desc: Compile-time random bits for hardware generation seed
          type: keymgr_pkg::seed_t
          randcount: 256
          randtype: data
          name_top: RndCnstKeymgrDpeHardOutputSeed
          default: 0xba5f8d8ff25c89c045cafb05418dfbe8d7fcbbefecd0724d145309f44aaff187
          randwidth: 256
        }
        {
          name: RndCnstAesSeed
          desc: Compile-time random bits for generation seed when aes destination selected
          type: keymgr_pkg::seed_t
          randcount: 256
          randtype: data
          name_top: RndCnstKeymgrDpeAesSeed
          default: 0x2ff7e1093995149ec31009401fd157bb84a905b2c5f9c732916d3f0a01064f24
          randwidth: 256
        }
        {
          name: RndCnstKmacSeed
          desc: Compile-time random bits for generation seed when kmac destination selected
          type: keymgr_pkg::seed_t
          randcount: 256
          randtype: data
          name_top: RndCnstKeymgrDpeKmacSeed
          default: 0xea0465a16890a37bb88177fbc4c9d8433b09b8115d90b55578192ba15b877a0
          randwidth: 256
        }
        {
          name: RndCnstOtbnSeed
          desc: Compile-time random bits for generation seed when otbn destination selected
          type: keymgr_pkg::seed_t
          randcount: 256
          randtype: data
          name_top: RndCnstKeymgrDpeOtbnSeed
          default: 0x14fb372cef558975129deae66bdcbef8597635d3effef7c250098fb964be41d6
          randwidth: 256
        }
        {
          name: RndCnstNoneSeed
          desc: Compile-time random bits for generation seed when no destination selected
          type: keymgr_pkg::seed_t
          randcount: 256
          randtype: data
          name_top: RndCnstKeymgrDpeNoneSeed
          default: 0x92b97c1669f1994b9663dfcce042f0b350714f7a42778626d3a6ac182db8d1a2
          randwidth: 256
        }
      ]
    }
    {
      name: csrng
      type: csrng
      base_addrs:
      {
        null:
        {
          hart: 0x21150000
        }
      }
      memory: {}
      param_list:
      [
        {
          name: RndCnstCsKeymgrDivNonProduction
          desc: Compile-time random bits for csrng state group diversification value
          type: csrng_pkg::cs_keymgr_div_t
          randcount: 384
          randtype: data
          name_top: RndCnstCsrngCsKeymgrDivNonProduction
          default: 0x21875bffbd69423adca64da6e21f0298923a2586b01b20884604567bc0249e2d8ab794a7633d9c6ecf883c940f9c5210
          randwidth: 384
        }
        {
          name: RndCnstCsKeymgrDivProduction
          desc: Compile-time random bits for csrng state group diversification value
          type: csrng_pkg::cs_keymgr_div_t
          randcount: 384
          randtype: data
          name_top: RndCnstCsrngCsKeymgrDivProduction
          default: 0xb3c586338402bdf1122beb15ea2fc002aae3aa4cdf001f7a0161dd19b6be6c3fa57aa970c83cc6c9148ecee6dbd6ea31
          randwidth: 384
        }
      ]
    }
    {
      name: sram_ctrl_main
      type: sram_ctrl
      base_addrs:
      {
        regs:
        {
          hart: 0x211c0000
        }
        ram:
        {
          hart: 0x10000000
        }
      }
      memory:
      {
        ram:
        {
          label: ram_main
          swaccess: rw
          data_intg_passthru: "true"
          exec: True
          byte_write: True
          size: 0x30000
        }
      }
      param_list:
      [
        {
          name: RndCnstSramKey
          desc: Compile-time random reset value for SRAM scrambling key.
          type: otp_ctrl_pkg::sram_key_t
          randcount: 128
          randtype: data
          name_top: RndCnstSramCtrlMainSramKey
          default: 0x69859159aebed647abb46389f3c15dc7
          randwidth: 128
        }
        {
          name: RndCnstSramNonce
          desc: Compile-time random reset value for SRAM scrambling nonce.
          type: otp_ctrl_pkg::sram_nonce_t
          randcount: 128
          randtype: data
          name_top: RndCnstSramCtrlMainSramNonce
          default: 0x8313d02eca038e9e13920507091a5b7a
          randwidth: 128
        }
        {
          name: RndCnstLfsrSeed
          desc: Compile-time random bits for initial LFSR seed
          type: sram_ctrl_pkg::lfsr_seed_t
          randcount: 64
          randtype: data
          name_top: RndCnstSramCtrlMainLfsrSeed
          default: 0x4275ffbb34d2938d
          randwidth: 64
        }
        {
          name: RndCnstLfsrPerm
          desc: Compile-time random permutation for LFSR output
          type: sram_ctrl_pkg::lfsr_perm_t
          randcount: 64
          randtype: perm
          name_top: RndCnstSramCtrlMainLfsrPerm
          default: 0x69cda6c874f8fa58fc09577703ba6afe134a3cb15950cd0e4480f9b275ae60482bc6fb5ef5f6e4252e908a8070d57cc6
          randwidth: 384
        }
      ]
    }
    {
      name: rom_ctrl
      type: rom_ctrl
      base_addrs:
      {
        rom:
        {
          hart: 0x00020000
        }
        regs:
        {
          hart: 0x211e0000
        }
      }
      memory:
      {
        rom:
        {
          label: rom
          swaccess: ro
          data_intg_passthru: True
          exec: True
          byte_write: False
          size: 0x20000
        }
      }
      param_list:
      [
        {
          name: RndCnstScrNonce
          desc: Fixed nonce used for address / data scrambling
          type: bit [63:0]
          randcount: 64
          randtype: data
          name_top: RndCnstRomCtrlScrNonce
          default: 0x911d539be4585cd8
          randwidth: 64
        }
        {
          name: RndCnstScrKey
          desc: Randomised constant used as a scrambling key for ROM data
          type: bit [127:0]
          randcount: 128
          randtype: data
          name_top: RndCnstRomCtrlScrKey
          default: 0x7ff2e1ba5327bc851a8140fcaeb768fd
          randwidth: 128
        }
      ]
    }
    {
      name: rv_core_ibex
      type: rv_core_ibex
      base_addrs:
      {
        cfg:
        {
          hart: 0x211f0000
        }
      }
      memory: {}
      param_list:
      [
        {
          name: RndCnstLfsrSeed
          desc: Default seed of the PRNG used for random instructions.
          type: ibex_pkg::lfsr_seed_t
          randcount: 32
          randtype: data
          name_top: RndCnstRvCoreIbexLfsrSeed
          default: 0x780c7bbb
          randwidth: 32
        }
        {
          name: RndCnstLfsrPerm
          desc: Permutation applied to the LFSR of the PRNG used for random instructions.
          type: ibex_pkg::lfsr_perm_t
          randcount: 32
          randtype: perm
          name_top: RndCnstRvCoreIbexLfsrPerm
          default: 0x2339d2b678809ea47bf51e4db0c80e3e969a46d7
          randwidth: 160
        }
        {
          name: RndCnstIbexKeyDefault
          desc: Default icache scrambling key
          type: logic [ibex_pkg::SCRAMBLE_KEY_W-1:0]
          randcount: 128
          randtype: data
          name_top: RndCnstRvCoreIbexIbexKeyDefault
          default: 0x78bc92eb252479ece1502f2c333b1543
          randwidth: 128
        }
        {
          name: RndCnstIbexNonceDefault
          desc: Default icache scrambling nonce
          type: logic [ibex_pkg::SCRAMBLE_NONCE_W-1:0]
          randcount: 64
          randtype: data
          name_top: RndCnstRvCoreIbexIbexNonceDefault
          default: 0x64fd06d4ceb894c6
          randwidth: 64
        }
      ]
      template_type: rv_core_ibex
    }
  ]
}
