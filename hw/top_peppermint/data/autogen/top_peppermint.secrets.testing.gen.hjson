// Copyright lowRISC contributors (OpenTitan project).
// Licensed under the Apache License, Version 2.0, see LICENSE for details.
// SPDX-License-Identifier: Apache-2.0
//
// ------------------- W A R N I N G: A U T O - G E N E R A T E D   C O D E !! -------------------//
// PLEASE DO NOT HAND-EDIT THIS FILE. IT HAS BEEN AUTO-GENERATED WITH THE FOLLOWING COMMAND:
// util/topgen.py -t hw/top_peppermint/data/top_peppermint.hjson
//                -o hw/top_peppermint/
{
  seed:
  {
    topgen_seed:
    {
      seed_mode: testing
      value: 51451787542291517751888767411848989252412020777091149863881806945777355144337
    }
    otp_img_seed:
    {
      seed_mode: testing
      value: 24868028277047070845280224376993946593238997617476146683055290474876205000801
    }
    lc_ctrl_seed:
    {
      seed_mode: testing
      value: 49841089124658132456165265978197681960561948696349021308850918515200439523606
    }
  }
  module:
  [
    {
      name: otp_ctrl
      type: otp_ctrl
      base_addrs:
      {
        core:
        {
          hart: 0x40010000
        }
      }
      memory: {}
      param_list:
      [
        {
          name: RndCnstLfsrSeed
          desc: Compile-time random bits for initial LFSR seed
          type: otp_ctrl_top_specific_pkg::lfsr_seed_t
          randcount: 40
          randtype: data
          name_top: RndCnstOtpCtrlLfsrSeed
          default: 0x625b39dd88
          randwidth: 40
        }
        {
          name: RndCnstLfsrPerm
          desc: Compile-time random permutation for LFSR output
          type: otp_ctrl_top_specific_pkg::lfsr_perm_t
          randcount: 40
          randtype: perm
          name_top: RndCnstOtpCtrlLfsrPerm
          default: 0x2c08cc3c12198606d179f2535249449d649a1425621c661c29738d990743
          randwidth: 240
        }
        {
          name: RndCnstScrmblKeyInit
          desc: Compile-time random permutation for scrambling key/nonce register reset value
          type: otp_ctrl_top_specific_pkg::scrmbl_key_init_t
          randcount: 256
          randtype: data
          name_top: RndCnstOtpCtrlScrmblKeyInit
          default: 0x2610a62d08f074ce9d1b8c9a8d23f56fd2c1a29eea9c28b881457ddd29cda674
          randwidth: 256
        }
        {
          name: RndCnstScrmblKey0
          desc: Compile-time scrambling key
          type: otp_ctrl_top_specific_pkg::key_t
          randcount: 128
          randtype: extdata
          name_top: RndCnstOtpCtrlScrmblKey0
          default: 0x98935387d84d189e94d201d4ca6d258f
          randwidth: 128
        }
        {
          name: RndCnstScrmblKey1
          desc: Compile-time scrambling key
          type: otp_ctrl_top_specific_pkg::key_t
          randcount: 128
          randtype: extdata
          name_top: RndCnstOtpCtrlScrmblKey1
          default: 0x957c6a0c9c087e73f96d33de76437066
          randwidth: 128
        }
        {
          name: RndCnstScrmblKey2
          desc: Compile-time scrambling key
          type: otp_ctrl_top_specific_pkg::key_t
          randcount: 128
          randtype: extdata
          name_top: RndCnstOtpCtrlScrmblKey2
          default: 0xe6efaa7743364fabfdadba1867aef4a5
          randwidth: 128
        }
        {
          name: RndCnstScrmblKey3
          desc: Compile-time scrambling key
          type: otp_ctrl_top_specific_pkg::key_t
          randcount: 128
          randtype: extdata
          name_top: RndCnstOtpCtrlScrmblKey3
          default: 0x25d3438c679bc5e1e95b11249ca35dde
          randwidth: 128
        }
        {
          name: RndCnstDigestConst0
          desc: Compile-time digest const
          type: otp_ctrl_top_specific_pkg::digest_const_t
          randcount: 128
          randtype: extdata
          name_top: RndCnstOtpCtrlDigestConst0
          default: 0x32067e1786b83222d00054b2af120ff8
          randwidth: 128
        }
        {
          name: RndCnstDigestConst1
          desc: Compile-time digest const
          type: otp_ctrl_top_specific_pkg::digest_const_t
          randcount: 128
          randtype: extdata
          name_top: RndCnstOtpCtrlDigestConst1
          default: 0x86a0b2454cfa25b23b692148e188c5ca
          randwidth: 128
        }
        {
          name: RndCnstDigestIV0
          desc: Compile-time digest initial vector
          type: otp_ctrl_top_specific_pkg::digest_iv_t
          randcount: 64
          randtype: extdata
          name_top: RndCnstOtpCtrlDigestIV0
          default: 0x49b7c7cd1734b80e
          randwidth: 64
        }
        {
          name: RndCnstDigestIV1
          desc: Compile-time digest initial vector
          type: otp_ctrl_top_specific_pkg::digest_iv_t
          randcount: 64
          randtype: extdata
          name_top: RndCnstOtpCtrlDigestIV1
          default: 0x1ae014cefd7de2cb
          randwidth: 64
        }
        {
          name: RndCnstPartInvDefault
          desc: OTP invalid partition default for buffered partitions
          type: logic [39807:0]
          randcount: 39808
          randtype: extdata
          name_top: RndCnstOtpCtrlPartInvDefault
          default:
          [
            {
              size: 704
              items:
              [
                {
                  size: 320
                  inv_default: 508406651299787982309904825443985373106236637081727939090585644961445206666689630393817246511712
                }
                {
                  size: 384
                  inv_default: 34765581757057702526568169959179506991796799849684129792408382543682161064351438550357191642801906499564079722040959
                }
              ]
            }
            {
              size: 384
              items:
              [
                {
                  size: 64
                  inv_default: 0
                }
                {
                  size: 64
                  inv_default: 10297274993151818246
                }
                {
                  size: 256
                  inv_default: 10206999105613237488305124545664851698610302080045852370886952986780297145526
                }
              ]
            }
            {
              size: 1024
              items:
              [
                {
                  size: 64
                  inv_default: 0
                }
                {
                  size: 64
                  inv_default: 16862586926326724172
                }
                {
                  size: 256
                  inv_default: 63999019030607151289909366880942569362330468042440373196189507388017079630937
                }
                {
                  size: 256
                  inv_default: 81109909720667310531206694470923378649726943238131960830210841988782597012480
                }
                {
                  size: 256
                  inv_default: 58428367318477997995158430436185008200278041856729653820014384131744449381794
                }
                {
                  size: 128
                  inv_default: 257151471457813701810792034009910885873
                }
              ]
            }
            {
              size: 256
              items:
              [
                {
                  size: 64
                  inv_default: 0
                }
                {
                  size: 64
                  inv_default: 12446391818523284464
                }
                {
                  size: 128
                  inv_default: 119626835793529483393158377097849370351
                }
              ]
            }
            {
              size: 384
              items:
              [
                {
                  size: 64
                  inv_default: 0
                }
                {
                  size: 64
                  inv_default: 10065874593229139721
                }
                {
                  size: 128
                  inv_default: 8049454917427216925997827152549284667
                }
                {
                  size: 128
                  inv_default: 191985393975828609903709283012653827085
                }
              ]
            }
            {
              size: 128
              items:
              [
                {
                  size: 64
                  inv_default: 9673330360152269864
                }
                {
                  comment: unallocated space
                  size: 16
                  inv_default: 0
                }
                {
                  size: 8
                  inv_default: 105
                }
                {
                  size: 8
                  inv_default: 105
                }
                {
                  size: 32
                  inv_default: 0
                }
              ]
            }
            {
              size: 576
              items:
              [
                {
                  size: 64
                  inv_default: 8821601860276922949
                }
                {
                  size: 256
                  inv_default: 89960518397345998442210387957448911146016937697982416014732294109643662651482
                }
                {
                  size: 256
                  inv_default: 84636775181865843423447751136542243067225345129144998513113609321933118751675
                }
              ]
            }
            {
              size: 8192
              items:
              [
                {
                  size: 8192
                  inv_default: 0
                }
              ]
            }
            {
              size: 1088
              items:
              [
                {
                  size: 64
                  inv_default: 16898073465963608763
                }
                {
                  size: 1024
                  inv_default: 0
                }
              ]
            }
            {
              size: 1088
              items:
              [
                {
                  size: 64
                  inv_default: 14656815325044117528
                }
                {
                  size: 1024
                  inv_default: 0
                }
              ]
            }
            {
              size: 1088
              items:
              [
                {
                  size: 64
                  inv_default: 7544202290022723701
                }
                {
                  size: 1024
                  inv_default: 0
                }
              ]
            }
            {
              size: 1088
              items:
              [
                {
                  size: 64
                  inv_default: 6297967080745773217
                }
                {
                  size: 1024
                  inv_default: 0
                }
              ]
            }
            {
              size: 1088
              items:
              [
                {
                  size: 64
                  inv_default: 4275689744169575455
                }
                {
                  size: 1024
                  inv_default: 0
                }
              ]
            }
            {
              size: 1088
              items:
              [
                {
                  size: 64
                  inv_default: 10448767896760702259
                }
                {
                  size: 1024
                  inv_default: 0
                }
              ]
            }
            {
              size: 1088
              items:
              [
                {
                  size: 64
                  inv_default: 5650730686695884436
                }
                {
                  size: 1024
                  inv_default: 0
                }
              ]
            }
            {
              size: 1088
              items:
              [
                {
                  size: 64
                  inv_default: 4036071169128675423
                }
                {
                  size: 1024
                  inv_default: 0
                }
              ]
            }
            {
              size: 11392
              items:
              [
                {
                  size: 64
                  inv_default: 15819321713790451465
                }
                {
                  comment: unallocated space
                  size: 32
                  inv_default: 0
                }
                {
                  size: 6144
                  inv_default: 0
                }
                {
                  size: 1280
                  inv_default: 0
                }
                {
                  size: 1280
                  inv_default: 0
                }
                {
                  size: 1280
                  inv_default: 0
                }
                {
                  size: 32
                  inv_default: 0
                }
                {
                  size: 1280
                  inv_default: 0
                }
              ]
            }
            {
              size: 256
              items:
              [
                {
                  size: 128
                  inv_default: 0
                }
                {
                  size: 128
                  inv_default: 0
                }
              ]
            }
            {
              size: 4800
              items:
              [
                {
                  size: 64
                  inv_default: 4123931682964426286
                }
                {
                  size: 32
                  inv_default: 0
                }
                {
                  size: 32
                  inv_default: 0
                }
                {
                  size: 32
                  inv_default: 0
                }
                {
                  size: 32
                  inv_default: 0
                }
                {
                  size: 32
                  inv_default: 0
                }
                {
                  size: 32
                  inv_default: 0
                }
                {
                  size: 32
                  inv_default: 0
                }
                {
                  size: 32
                  inv_default: 0
                }
                {
                  size: 512
                  inv_default: 0
                }
                {
                  size: 128
                  inv_default: 0
                }
                {
                  size: 128
                  inv_default: 0
                }
                {
                  size: 224
                  inv_default: 0
                }
                {
                  size: 3360
                  inv_default: 0
                }
                {
                  size: 32
                  inv_default: 0
                }
                {
                  size: 32
                  inv_default: 0
                }
                {
                  size: 32
                  inv_default: 0
                }
                {
                  size: 32
                  inv_default: 0
                }
              ]
            }
            {
              size: 2496
              items:
              [
                {
                  size: 64
                  inv_default: 7512587968106004660
                }
                {
                  comment: unallocated space
                  size: 32
                  inv_default: 0
                }
                {
                  size: 32
                  inv_default: 0
                }
                {
                  size: 32
                  inv_default: 0
                }
                {
                  size: 32
                  inv_default: 0
                }
                {
                  size: 32
                  inv_default: 0
                }
                {
                  size: 32
                  inv_default: 0
                }
                {
                  size: 32
                  inv_default: 0
                }
                {
                  size: 32
                  inv_default: 0
                }
                {
                  size: 32
                  inv_default: 0
                }
                {
                  size: 32
                  inv_default: 0
                }
                {
                  size: 32
                  inv_default: 0
                }
                {
                  size: 32
                  inv_default: 0
                }
                {
                  size: 32
                  inv_default: 0
                }
                {
                  size: 32
                  inv_default: 0
                }
                {
                  size: 32
                  inv_default: 0
                }
                {
                  size: 32
                  inv_default: 0
                }
                {
                  size: 32
                  inv_default: 0
                }
                {
                  size: 32
                  inv_default: 0
                }
                {
                  size: 32
                  inv_default: 0
                }
                {
                  size: 32
                  inv_default: 0
                }
                {
                  size: 32
                  inv_default: 0
                }
                {
                  size: 32
                  inv_default: 0
                }
                {
                  size: 32
                  inv_default: 0
                }
                {
                  size: 32
                  inv_default: 0
                }
                {
                  size: 32
                  inv_default: 0
                }
                {
                  size: 32
                  inv_default: 0
                }
                {
                  size: 32
                  inv_default: 0
                }
                {
                  size: 32
                  inv_default: 0
                }
                {
                  size: 32
                  inv_default: 0
                }
                {
                  size: 64
                  inv_default: 0
                }
                {
                  size: 32
                  inv_default: 0
                }
                {
                  size: 64
                  inv_default: 0
                }
                {
                  size: 32
                  inv_default: 0
                }
                {
                  size: 32
                  inv_default: 0
                }
                {
                  size: 256
                  inv_default: 0
                }
                {
                  size: 32
                  inv_default: 0
                }
                {
                  size: 992
                  inv_default: 0
                }
              ]
            }
            {
              size: 512
              items:
              [
                {
                  size: 64
                  inv_default: 13995797430872360414
                }
                {
                  size: 448
                  inv_default: 0
                }
              ]
            }
          ]
          randwidth: 39808
        }
      ]
      template_type: otp_ctrl
      otp_mmap:
      {
        otp:
        {
          width: 2
          depth: 4096
          size: 8192
          addr_width: 12
          byte_addr_width: 13
        }
        scrambling:
        {
          key_size: 16
          iv_size: 8
          cnst_size: 16
          keys:
          [
            {
              name: Secret0Key
              value: 202807617200252840528729068358060549519
            }
            {
              name: Secret1Key
              value: 198700967116856651033054259582582616166
            }
            {
              name: Secret2Key
              value: 306966855438305588444436821114459452581
            }
            {
              name: Secret3Key
              value: 50278380526644206573154867505977843166
            }
          ]
          digests:
          [
            {
              name: CnstyDigest
              iv_value: 5311933969178343438
              cnst_value: 66495111017948470976885563649124601848
            }
            {
              name: SramDataKey
              iv_value: 1936570719018017483
              cnst_value: 178950934692020233087936965387133437386
            }
          ]
          num_keys: 4
          num_digests: 2
        }
        partitions:
        [
          {
            name: VENDOR_TEST
            variant: Unbuffered
            absorb: false
            secret: false
            sw_digest: true
            hw_digest: false
            write_lock: Digest
            read_lock: CSR
            key_sel: NoKey
            integrity: false
            bkout_type: false
            zeroizable: false
            skip_sw_header: true
            items:
            [
              {
                name: SCRATCH
                size: 56
                isdigest: false
                iszer: false
                ismubi: false
                iskeymgr_creator: false
                iskeymgr_owner: false
                inv_default: 0
                offset: 0
              }
              {
                name: VENDOR_TEST_DIGEST
                size: 8
                offset: 56
                ismubi: false
                isdigest: true
                iszer: false
                inv_default: 13995797430872360414
                iskeymgr_creator: false
                iskeymgr_owner: false
              }
            ]
            desc:
              '''
              Vendor test partition.
              This is reserved for manufacturing smoke checks. The OTP wrapper
              control logic inside prim_otp is allowed to read/write to this
              region. ECC uncorrectable errors seen on the functional prim_otp
              interface will not lead to an alert for this partition.
              Instead, such errors will be reported as correctable ECC errors.
              '''
            iskeymgr_creator: false
            iskeymgr_owner: false
            ignore_read_lock_in_rma: false
            size: 64
            offset: 0
          }
          {
            name: CREATOR_SW_CFG
            variant: Unbuffered
            absorb: false
            secret: false
            sw_digest: true
            hw_digest: false
            write_lock: Digest
            read_lock: CSR
            key_sel: NoKey
            integrity: true
            bkout_type: false
            zeroizable: false
            items:
            [
              {
                name: CREATOR_SW_CFG_AST_CFG
                size: 124
                isdigest: false
                iszer: false
                ismubi: false
                iskeymgr_creator: false
                iskeymgr_owner: false
                inv_default: 0
                offset: 64
              }
              {
                name: CREATOR_SW_CFG_AST_INIT_EN
                size: 4
                isdigest: false
                iszer: false
                ismubi: false
                iskeymgr_creator: false
                iskeymgr_owner: false
                inv_default: 0
                offset: 188
              }
              {
                name: CREATOR_SW_CFG_OVERRIDES
                size: 32
                isdigest: false
                iszer: false
                ismubi: false
                iskeymgr_creator: false
                iskeymgr_owner: false
                inv_default: 0
                offset: 192
              }
              {
                name: CREATOR_SW_CFG_ROM_EXT_SKU
                size: 4
                isdigest: false
                iszer: false
                ismubi: false
                iskeymgr_creator: false
                iskeymgr_owner: false
                inv_default: 0
                offset: 224
              }
              {
                name: CREATOR_SW_CFG_SIGVERIFY_RSA_MOD_EXP_IBEX_EN
                size: 4
                isdigest: false
                iszer: false
                ismubi: false
                iskeymgr_creator: false
                iskeymgr_owner: false
                inv_default: 0
                offset: 228
              }
              {
                name: CREATOR_SW_CFG_SIGVERIFY_RSA_KEY_EN
                size: 8
                isdigest: false
                iszer: false
                ismubi: false
                iskeymgr_creator: false
                iskeymgr_owner: false
                inv_default: 0
                offset: 232
              }
              {
                name: CREATOR_SW_CFG_SIGVERIFY_SPX_EN
                size: 4
                isdigest: false
                iszer: false
                ismubi: false
                iskeymgr_creator: false
                iskeymgr_owner: false
                inv_default: 0
                offset: 240
              }
              {
                name: CREATOR_SW_CFG_SIGVERIFY_SPX_KEY_EN
                size: 8
                isdigest: false
                iszer: false
                ismubi: false
                iskeymgr_creator: false
                iskeymgr_owner: false
                inv_default: 0
                offset: 244
              }
              {
                name: CREATOR_SW_CFG_FLASH_DATA_DEFAULT_CFG
                size: 4
                isdigest: false
                iszer: false
                ismubi: false
                iskeymgr_creator: false
                iskeymgr_owner: false
                inv_default: 0
                offset: 252
              }
              {
                name: CREATOR_SW_CFG_FLASH_INFO_BOOT_DATA_CFG
                size: 4
                isdigest: false
                iszer: false
                ismubi: false
                iskeymgr_creator: false
                iskeymgr_owner: false
                inv_default: 0
                offset: 256
              }
              {
                name: CREATOR_SW_CFG_FLASH_HW_INFO_CFG_OVERRIDE
                size: 4
                isdigest: false
                iszer: false
                ismubi: false
                iskeymgr_creator: false
                iskeymgr_owner: false
                inv_default: 0
                offset: 260
              }
              {
                name: CREATOR_SW_CFG_RNG_EN
                size: 4
                isdigest: false
                iszer: false
                ismubi: false
                iskeymgr_creator: false
                iskeymgr_owner: false
                inv_default: 0
                offset: 264
              }
              {
                name: CREATOR_SW_CFG_JITTER_EN
                size: 4
                isdigest: false
                iszer: false
                ismubi: false
                iskeymgr_creator: false
                iskeymgr_owner: false
                inv_default: 0
                offset: 268
              }
              {
                name: CREATOR_SW_CFG_RET_RAM_RESET_MASK
                size: 4
                isdigest: false
                iszer: false
                ismubi: false
                iskeymgr_creator: false
                iskeymgr_owner: false
                inv_default: 0
                offset: 272
              }
              {
                name: CREATOR_SW_CFG_MANUF_STATE
                size: 4
                isdigest: false
                iszer: false
                ismubi: false
                iskeymgr_creator: false
                iskeymgr_owner: false
                inv_default: 0
                offset: 276
              }
              {
                name: CREATOR_SW_CFG_ROM_EXEC_EN
                size: 4
                isdigest: false
                iszer: false
                ismubi: false
                iskeymgr_creator: false
                iskeymgr_owner: false
                inv_default: 0
                offset: 280
              }
              {
                name: CREATOR_SW_CFG_CPUCTRL
                size: 4
                isdigest: false
                iszer: false
                ismubi: false
                iskeymgr_creator: false
                iskeymgr_owner: false
                inv_default: 0
                offset: 284
              }
              {
                name: CREATOR_SW_CFG_MIN_SEC_VER_ROM_EXT
                size: 4
                isdigest: false
                iszer: false
                ismubi: false
                iskeymgr_creator: false
                iskeymgr_owner: false
                inv_default: 0
                offset: 288
              }
              {
                name: CREATOR_SW_CFG_MIN_SEC_VER_BL0
                size: 4
                isdigest: false
                iszer: false
                ismubi: false
                iskeymgr_creator: false
                iskeymgr_owner: false
                inv_default: 0
                offset: 292
              }
              {
                name: CREATOR_SW_CFG_DEFAULT_BOOT_DATA_IN_PROD_EN
                size: 4
                isdigest: false
                iszer: false
                ismubi: false
                iskeymgr_creator: false
                iskeymgr_owner: false
                inv_default: 0
                offset: 296
              }
              {
                name: CREATOR_SW_CFG_RMA_SPIN_EN
                size: 4
                isdigest: false
                iszer: false
                ismubi: false
                iskeymgr_creator: false
                iskeymgr_owner: false
                inv_default: 0
                offset: 300
              }
              {
                name: CREATOR_SW_CFG_RMA_SPIN_CYCLES
                size: 4
                isdigest: false
                iszer: false
                ismubi: false
                iskeymgr_creator: false
                iskeymgr_owner: false
                inv_default: 0
                offset: 304
              }
              {
                name: CREATOR_SW_CFG_RNG_REPCNT_THRESHOLDS
                size: 4
                isdigest: false
                iszer: false
                ismubi: false
                iskeymgr_creator: false
                iskeymgr_owner: false
                inv_default: 0
                offset: 308
              }
              {
                name: CREATOR_SW_CFG_RNG_REPCNTS_THRESHOLDS
                size: 4
                isdigest: false
                iszer: false
                ismubi: false
                iskeymgr_creator: false
                iskeymgr_owner: false
                inv_default: 0
                offset: 312
              }
              {
                name: CREATOR_SW_CFG_RNG_ADAPTP_HI_THRESHOLDS
                size: 4
                isdigest: false
                iszer: false
                ismubi: false
                iskeymgr_creator: false
                iskeymgr_owner: false
                inv_default: 0
                offset: 316
              }
              {
                name: CREATOR_SW_CFG_RNG_ADAPTP_LO_THRESHOLDS
                size: 4
                isdigest: false
                iszer: false
                ismubi: false
                iskeymgr_creator: false
                iskeymgr_owner: false
                inv_default: 0
                offset: 320
              }
              {
                name: CREATOR_SW_CFG_RNG_BUCKET_THRESHOLDS
                size: 4
                isdigest: false
                iszer: false
                ismubi: false
                iskeymgr_creator: false
                iskeymgr_owner: false
                inv_default: 0
                offset: 324
              }
              {
                name: CREATOR_SW_CFG_RNG_MARKOV_HI_THRESHOLDS
                size: 4
                isdigest: false
                iszer: false
                ismubi: false
                iskeymgr_creator: false
                iskeymgr_owner: false
                inv_default: 0
                offset: 328
              }
              {
                name: CREATOR_SW_CFG_RNG_MARKOV_LO_THRESHOLDS
                size: 4
                isdigest: false
                iszer: false
                ismubi: false
                iskeymgr_creator: false
                iskeymgr_owner: false
                inv_default: 0
                offset: 332
              }
              {
                name: CREATOR_SW_CFG_RNG_EXTHT_HI_THRESHOLDS
                size: 4
                isdigest: false
                iszer: false
                ismubi: false
                iskeymgr_creator: false
                iskeymgr_owner: false
                inv_default: 0
                offset: 336
              }
              {
                name: CREATOR_SW_CFG_RNG_EXTHT_LO_THRESHOLDS
                size: 4
                isdigest: false
                iszer: false
                ismubi: false
                iskeymgr_creator: false
                iskeymgr_owner: false
                inv_default: 0
                offset: 340
              }
              {
                name: CREATOR_SW_CFG_RNG_BOOT_ALERT_THRESHOLD
                size: 4
                isdigest: false
                iszer: false
                ismubi: false
                iskeymgr_creator: false
                iskeymgr_owner: false
                inv_default: 0
                offset: 344
              }
              {
                name: CREATOR_SW_CFG_RNG_FIPS_ALERT_THRESHOLD
                size: 4
                isdigest: false
                iszer: false
                ismubi: false
                iskeymgr_creator: false
                iskeymgr_owner: false
                inv_default: 0
                offset: 348
              }
              {
                name: CREATOR_SW_CFG_RNG_BOOT_CONFIG_DIGEST
                size: 4
                isdigest: false
                iszer: false
                ismubi: false
                iskeymgr_creator: false
                iskeymgr_owner: false
                inv_default: 0
                offset: 352
              }
              {
                name: CREATOR_SW_CFG_RNG_FIPS_CONFIG_DIGEST
                size: 4
                isdigest: false
                iszer: false
                ismubi: false
                iskeymgr_creator: false
                iskeymgr_owner: false
                inv_default: 0
                offset: 356
              }
              {
                name: CREATOR_SW_CFG_SRAM_KEY_RENEW_AND_INIT_EN
                size: 4
                isdigest: false
                iszer: false
                ismubi: false
                iskeymgr_creator: false
                iskeymgr_owner: false
                inv_default: 0
                offset: 360
              }
              {
                name: CREATOR_SW_CFG_DIGEST
                size: 8
                offset: 368
                ismubi: false
                isdigest: true
                iszer: false
                inv_default: 7512587968106004660
                iskeymgr_creator: false
                iskeymgr_owner: false
              }
            ]
            desc:
              '''
              Software configuration partition.
              This is for device-specific calibration data. For example, clock,
              LDO, RNG.
              '''
            iskeymgr_creator: false
            iskeymgr_owner: false
            ignore_read_lock_in_rma: false
            size: 312
            offset: 64
          }
          {
            name: OWNER_SW_CFG
            variant: Unbuffered
            absorb: false
            secret: false
            sw_digest: true
            hw_digest: false
            write_lock: Digest
            read_lock: CSR
            key_sel: NoKey
            integrity: true
            bkout_type: false
            zeroizable: false
            items:
            [
              {
                name: OWNER_SW_CFG_ROM_ERROR_REPORTING
                size: 4
                isdigest: false
                iszer: false
                ismubi: false
                iskeymgr_creator: false
                iskeymgr_owner: false
                inv_default: 0
                offset: 376
              }
              {
                name: OWNER_SW_CFG_ROM_BOOTSTRAP_DIS
                size: 4
                isdigest: false
                iszer: false
                ismubi: false
                iskeymgr_creator: false
                iskeymgr_owner: false
                inv_default: 0
                offset: 380
              }
              {
                name: OWNER_SW_CFG_ROM_ALERT_CLASS_EN
                size: 4
                isdigest: false
                iszer: false
                ismubi: false
                iskeymgr_creator: false
                iskeymgr_owner: false
                inv_default: 0
                offset: 384
              }
              {
                name: OWNER_SW_CFG_ROM_ALERT_ESCALATION
                size: 4
                isdigest: false
                iszer: false
                ismubi: false
                iskeymgr_creator: false
                iskeymgr_owner: false
                inv_default: 0
                offset: 388
              }
              {
                name: OWNER_SW_CFG_ROM_ALERT_CLASSIFICATION
                size: 420
                isdigest: false
                iszer: false
                ismubi: false
                iskeymgr_creator: false
                iskeymgr_owner: false
                inv_default: 0
                offset: 392
              }
              {
                name: OWNER_SW_CFG_ROM_LOCAL_ALERT_CLASSIFICATION
                size: 28
                isdigest: false
                iszer: false
                ismubi: false
                iskeymgr_creator: false
                iskeymgr_owner: false
                inv_default: 0
                offset: 812
              }
              {
                name: OWNER_SW_CFG_ROM_ALERT_ACCUM_THRESH
                size: 16
                isdigest: false
                iszer: false
                ismubi: false
                iskeymgr_creator: false
                iskeymgr_owner: false
                inv_default: 0
                offset: 840
              }
              {
                name: OWNER_SW_CFG_ROM_ALERT_TIMEOUT_CYCLES
                size: 16
                isdigest: false
                iszer: false
                ismubi: false
                iskeymgr_creator: false
                iskeymgr_owner: false
                inv_default: 0
                offset: 856
              }
              {
                name: OWNER_SW_CFG_ROM_ALERT_PHASE_CYCLES
                size: 64
                isdigest: false
                iszer: false
                ismubi: false
                iskeymgr_creator: false
                iskeymgr_owner: false
                inv_default: 0
                offset: 872
              }
              {
                name: OWNER_SW_CFG_ROM_ALERT_DIGEST_PROD
                size: 4
                isdigest: false
                iszer: false
                ismubi: false
                iskeymgr_creator: false
                iskeymgr_owner: false
                inv_default: 0
                offset: 936
              }
              {
                name: OWNER_SW_CFG_ROM_ALERT_DIGEST_PROD_END
                size: 4
                isdigest: false
                iszer: false
                ismubi: false
                iskeymgr_creator: false
                iskeymgr_owner: false
                inv_default: 0
                offset: 940
              }
              {
                name: OWNER_SW_CFG_ROM_ALERT_DIGEST_DEV
                size: 4
                isdigest: false
                iszer: false
                ismubi: false
                iskeymgr_creator: false
                iskeymgr_owner: false
                inv_default: 0
                offset: 944
              }
              {
                name: OWNER_SW_CFG_ROM_ALERT_DIGEST_RMA
                size: 4
                isdigest: false
                iszer: false
                ismubi: false
                iskeymgr_creator: false
                iskeymgr_owner: false
                inv_default: 0
                offset: 948
              }
              {
                name: OWNER_SW_CFG_ROM_WATCHDOG_BITE_THRESHOLD_CYCLES
                size: 4
                isdigest: false
                iszer: false
                ismubi: false
                iskeymgr_creator: false
                iskeymgr_owner: false
                inv_default: 0
                offset: 952
              }
              {
                name: OWNER_SW_CFG_ROM_KEYMGR_ROM_EXT_MEAS_EN
                size: 4
                isdigest: false
                iszer: false
                ismubi: false
                iskeymgr_creator: false
                iskeymgr_owner: false
                inv_default: 0
                offset: 956
              }
              {
                name: OWNER_SW_CFG_MANUF_STATE
                size: 4
                isdigest: false
                iszer: false
                ismubi: false
                iskeymgr_creator: false
                iskeymgr_owner: false
                inv_default: 0
                offset: 960
              }
              {
                name: OWNER_SW_CFG_ROM_RSTMGR_INFO_EN
                size: 4
                isdigest: false
                iszer: false
                ismubi: false
                iskeymgr_creator: false
                iskeymgr_owner: false
                inv_default: 0
                offset: 964
              }
              {
                name: OWNER_SW_CFG_DIGEST
                size: 8
                offset: 968
                ismubi: false
                isdigest: true
                iszer: false
                inv_default: 4123931682964426286
                iskeymgr_creator: false
                iskeymgr_owner: false
              }
            ]
            desc:
              '''
              Software configuration partition.
              This contains data that changes software behavior in the ROM, for
              example enabling defensive features in ROM or selecting failure
              modes if verification fails.
              '''
            iskeymgr_creator: false
            iskeymgr_owner: false
            ignore_read_lock_in_rma: false
            size: 600
            offset: 376
          }
          {
            name: AUTH_SLOT_STATE
            variant: Unbuffered
            absorb: false
            secret: false
            sw_digest: false
            hw_digest: false
            write_lock: None
            read_lock: CSR
            key_sel: NoKey
            integrity: true
            bkout_type: false
            zeroizable: false
            items:
            [
              {
                name: AUTH_SLOT_STATE_ROT_FIRMWARE
                size: 16
                desc:
                  '''
                  RoT Firmware Auth Slot State
                  SLOT_ST_RAW:       slot not yet claimed (factory default)
                  SLOT_ST_LOCKED0:   first slot claimed
                  SLOT_ST_RELEASED0: first slot released (assets have been cleared, ready to xfer)
                  SLOT_ST_LOCKED1:   second slot claimed
                  SLOT_ST_RELEASED1: second slot released (assets have been cleared, ready to xfer)
                  SLOT_ST_LOCKED2:   third slot claimed
                  SLOT_ST_RELEASED2: third slot released (assets have been cleared, ready to xfer)
                  SLOT_ST_LOCKED3:   fourth slot claimed
                  SLOT_ST_SCRAPPED:  scrap state - terminal
                  '''
                isdigest: false
                iszer: false
                ismubi: false
                iskeymgr_creator: false
                iskeymgr_owner: false
                inv_default: 0
                offset: 976
              }
              {
                name: AUTH_SLOT_STATE_SOC_FIRMWARE
                size: 16
                desc:
                  '''
                  SoC Firmware Key Slot State
                  SLOT_ST_RAW:       slot not yet claimed (factory default)
                  SLOT_ST_LOCKED0:   first slot claimed
                  SLOT_ST_RELEASED0: first slot released (assets have been cleared, ready to xfer)
                  SLOT_ST_LOCKED1:   second slot claimed
                  SLOT_ST_RELEASED1: second slot released (assets have been cleared, ready to xfer)
                  SLOT_ST_LOCKED2:   third slot claimed
                  SLOT_ST_RELEASED2: third slot released (assets have been cleared, ready to xfer)
                  SLOT_ST_LOCKED3:   fourth slot claimed
                  SLOT_ST_SCRAPPED:  scrap state - terminal
                  '''
                isdigest: false
                iszer: false
                ismubi: false
                iskeymgr_creator: false
                iskeymgr_owner: false
                inv_default: 0
                offset: 992
              }
            ]
            desc:
              '''
              SW managed authentication slot states partition.

              Multibit enable value for the tracking the authentication slot states.
              Note that the states can be written multiple times in a device lifetime.
              The values to be written are engineered in the same way as the LC_CTRL
              state encoding words so that the ECC encoding remains valid even after
              updating the values.

              The constants can be found in the lc_ctrl_state_pkg.sv package.

              The programming order has to adhere to:

              SLOT_ST_RAW (factory all-zero state) ->
              SLOT_ST_LOCKED0 ->
              SLOT_ST_RELEASED0 ->
              ...
              SLOT_ST_SCRAPPED

              Note that if there are less than 4 slots available the higher slot states
              become logically equivalent to SLOT_ST_SCRAPPED (firmware has to handle
              this correctly).
              '''
            iskeymgr_creator: false
            iskeymgr_owner: false
            ignore_read_lock_in_rma: false
            size: 32
            offset: 976
          }
          {
            name: ROT_CREATOR_AUTH
            variant: Unbuffered
            absorb: false
            secret: false
            sw_digest: true
            hw_digest: false
            write_lock: Digest
            read_lock: CSR
            key_sel: NoKey
            integrity: true
            bkout_type: false
            zeroizable: false
            items:
            [
              {
                name: ROT_CREATOR_AUTH_NON_RAW_MFW_CODESIGN_KEY
                size: 160
                desc:
                  '''
                  Pub Key used to verify the manufacturing provisioning Software container
                  160B = Custom Cert --> {PubKey:48, Signature:48, Device ID:32, metadata:16}
                  It is expected to be provisioned at Chip Probe stage when LC = TEST
                  i.e. provisioning protected under proper lifecycle logistics / secure supplychain management
                  '''
                isdigest: false
                iszer: false
                ismubi: false
                iskeymgr_creator: false
                iskeymgr_owner: false
                inv_default: 0
                offset: 1008
              }
              {
                name: ROT_CREATOR_AUTH_OWNERSHIP_STATE
                size: 4
                desc:
                  '''
                  Creator Ownership transfer state management
                  UNLOCKED - ownership of ROT not yet claimed
                  LOCKED   - ownership claimed and
                  RELEASED - Release ownership (assets have been cleared, ready to xfer)
                  '''
                isdigest: false
                iszer: false
                ismubi: false
                iskeymgr_creator: false
                iskeymgr_owner: false
                inv_default: 0
                offset: 1168
              }
              {
                name: ROT_CREATOR_AUTH_ROM2_PATCH_SIGVERIFY_KEY
                size: 160
                desc:
                  '''
                  Pub Key used to verify the ROM2 OTP based patch
                  160B = Custom Cert --> {PubKey:48, Signature:48, Device ID:32, metadata:16}
                  It is expected to be provisioned at Chip Probe stage when LC = TEST
                  i.e. provisioning protected under proper lifecycle logistics / secure supplychain management
                    OTP based key (instead of ROM) facilitates easy key rotation
                  '''
                isdigest: false
                iszer: false
                ismubi: false
                iskeymgr_creator: false
                iskeymgr_owner: false
                inv_default: 0
                offset: 1172
              }
              {
                name: ROT_CREATOR_AUTH_KEYMANIFEST_KEY
                size: 160
                desc:
                  '''
                  Pub Key used to verify the ROT CREATOR KEY MANIFEST.
                  KM is used to provisioning additional keys in (external) flash
                  160B = Custom Cert --> {PubKey:48, Signature:48, Device ID:32, metadata:16}
                  It is expected to be provisioned at Chip Probe stage when LC = TEST
                  i.e. provisioning protected under proper lifecycle logistics / secure supplychain management
                  '''
                isdigest: false
                iszer: false
                ismubi: false
                iskeymgr_creator: false
                iskeymgr_owner: false
                inv_default: 0
                offset: 1332
              }
              {
                name: ROT_CREATOR_AUTH_UNLOCK4XFER_KEY
                size: 160
                desc:
                  '''
                  Pub Key used to verify the ROT CREATOR KEY MANIFEST.
                  Used to authenticate the Unlock Ownership payload. Key Type: ECC NIST-P384 Curve.
                  160B = Custom Cert --> {PubKey:48, Signature:48, Device ID:32, metadata:16}
                  Can be made part bound i.e. unique per part key cert
                  i.e. provisioning protected under proper lifecycle logistics / secure supplychain management
                  '''
                isdigest: false
                iszer: false
                ismubi: false
                iskeymgr_creator: false
                iskeymgr_owner: false
                inv_default: 0
                offset: 1492
              }
              {
                name: ROT_CREATOR_AUTH_IDENTITY_CERT
                size: 768
                desc: ROT Device Identity Certificate endorsed by Silicon Creator stable off device PKI
                isdigest: false
                iszer: false
                ismubi: false
                iskeymgr_creator: false
                iskeymgr_owner: false
                inv_default: 0
                offset: 1652
              }
              {
                name: ROT_CREATOR_AUTH_DIGEST
                size: 8
                offset: 2424
                ismubi: false
                isdigest: true
                iszer: false
                inv_default: 15819321713790451465
                iskeymgr_creator: false
                iskeymgr_owner: false
              }
            ]
            desc: Software managed creator partition.
            iskeymgr_creator: false
            iskeymgr_owner: false
            ignore_read_lock_in_rma: false
            size: 1424
            offset: 1008
          }
          {
            name: ROT_FIRMWARE_AUTH_SLOT0
            variant: Unbuffered
            absorb: false
            secret: false
            sw_digest: true
            hw_digest: false
            write_lock: Digest
            read_lock: CSR
            key_sel: NoKey
            integrity: true
            bkout_type: false
            zeroizable: false
            items:
            [
              {
                name: ROT_FIRMWARE_AUTH_SLOT0_HASH
                size: 128
                desc: Hash of public key for RoT firmware (slot 0)
                isdigest: false
                iszer: false
                ismubi: false
                iskeymgr_creator: false
                iskeymgr_owner: false
                inv_default: 0
                offset: 2432
              }
              {
                name: ROT_FIRMWARE_AUTH_SLOT0_DIGEST
                size: 8
                offset: 2560
                ismubi: false
                isdigest: true
                iszer: false
                inv_default: 4036071169128675423
                iskeymgr_creator: false
                iskeymgr_owner: false
              }
            ]
            desc: Software managed RoT firmware authentication slot
            iskeymgr_creator: false
            iskeymgr_owner: false
            ignore_read_lock_in_rma: false
            size: 136
            offset: 2432
          }
          {
            name: ROT_FIRMWARE_AUTH_SLOT1
            variant: Unbuffered
            absorb: false
            secret: false
            sw_digest: true
            hw_digest: false
            write_lock: Digest
            read_lock: CSR
            key_sel: NoKey
            integrity: true
            bkout_type: false
            zeroizable: false
            items:
            [
              {
                name: ROT_FIRMWARE_AUTH_SLOT1_HASH
                size: 128
                desc: Hash of public key for RoT firmware (slot 1)
                isdigest: false
                iszer: false
                ismubi: false
                iskeymgr_creator: false
                iskeymgr_owner: false
                inv_default: 0
                offset: 2568
              }
              {
                name: ROT_FIRMWARE_AUTH_SLOT1_DIGEST
                size: 8
                offset: 2696
                ismubi: false
                isdigest: true
                iszer: false
                inv_default: 5650730686695884436
                iskeymgr_creator: false
                iskeymgr_owner: false
              }
            ]
            desc: Software managed RoT firmware authentication slot
            iskeymgr_creator: false
            iskeymgr_owner: false
            ignore_read_lock_in_rma: false
            size: 136
            offset: 2568
          }
          {
            name: ROT_FIRMWARE_AUTH_SLOT2
            variant: Unbuffered
            absorb: false
            secret: false
            sw_digest: true
            hw_digest: false
            write_lock: Digest
            read_lock: CSR
            key_sel: NoKey
            integrity: true
            bkout_type: false
            zeroizable: false
            items:
            [
              {
                name: ROT_FIRMWARE_AUTH_SLOT2_HASH
                size: 128
                desc: Hash of public key for RoT firmware (slot 2)
                isdigest: false
                iszer: false
                ismubi: false
                iskeymgr_creator: false
                iskeymgr_owner: false
                inv_default: 0
                offset: 2704
              }
              {
                name: ROT_FIRMWARE_AUTH_SLOT2_DIGEST
                size: 8
                offset: 2832
                ismubi: false
                isdigest: true
                iszer: false
                inv_default: 10448767896760702259
                iskeymgr_creator: false
                iskeymgr_owner: false
              }
            ]
            desc: Software managed RoT firmware authentication slot
            iskeymgr_creator: false
            iskeymgr_owner: false
            ignore_read_lock_in_rma: false
            size: 136
            offset: 2704
          }
          {
            name: ROT_FIRMWARE_AUTH_SLOT3
            variant: Unbuffered
            absorb: false
            secret: false
            sw_digest: true
            hw_digest: false
            write_lock: Digest
            read_lock: CSR
            key_sel: NoKey
            integrity: true
            bkout_type: false
            zeroizable: false
            items:
            [
              {
                name: ROT_FIRMWARE_AUTH_SLOT3_HASH
                size: 128
                desc: Hash of public key for RoT firmware (slot 3)
                isdigest: false
                iszer: false
                ismubi: false
                iskeymgr_creator: false
                iskeymgr_owner: false
                inv_default: 0
                offset: 2840
              }
              {
                name: ROT_FIRMWARE_AUTH_SLOT3_DIGEST
                size: 8
                offset: 2968
                ismubi: false
                isdigest: true
                iszer: false
                inv_default: 4275689744169575455
                iskeymgr_creator: false
                iskeymgr_owner: false
              }
            ]
            desc: Software managed RoT firmware authentication slot
            iskeymgr_creator: false
            iskeymgr_owner: false
            ignore_read_lock_in_rma: false
            size: 136
            offset: 2840
          }
          {
            name: SOC_FIRMWARE_AUTH_SLOT0
            variant: Unbuffered
            absorb: false
            secret: false
            sw_digest: true
            hw_digest: false
            write_lock: Digest
            read_lock: CSR
            key_sel: NoKey
            integrity: true
            bkout_type: false
            zeroizable: false
            items:
            [
              {
                name: SOC_FIRMWARE_AUTH_SLOT0_HASH
                size: 128
                desc: Hash of public key for SoC firmware (slot 0)
                isdigest: false
                iszer: false
                ismubi: false
                iskeymgr_creator: false
                iskeymgr_owner: false
                inv_default: 0
                offset: 2976
              }
              {
                name: SOC_FIRMWARE_AUTH_SLOT0_DIGEST
                size: 8
                offset: 3104
                ismubi: false
                isdigest: true
                iszer: false
                inv_default: 6297967080745773217
                iskeymgr_creator: false
                iskeymgr_owner: false
              }
            ]
            desc: Software managed SoC firmware authentication slot
            iskeymgr_creator: false
            iskeymgr_owner: false
            ignore_read_lock_in_rma: false
            size: 136
            offset: 2976
          }
          {
            name: SOC_FIRMWARE_AUTH_SLOT1
            variant: Unbuffered
            absorb: false
            secret: false
            sw_digest: true
            hw_digest: false
            write_lock: Digest
            read_lock: CSR
            key_sel: NoKey
            integrity: true
            bkout_type: false
            zeroizable: false
            items:
            [
              {
                name: SOC_FIRMWARE_AUTH_SLOT1_HASH
                size: 128
                desc: Hash of public key for SoC firmware (slot 1)
                isdigest: false
                iszer: false
                ismubi: false
                iskeymgr_creator: false
                iskeymgr_owner: false
                inv_default: 0
                offset: 3112
              }
              {
                name: SOC_FIRMWARE_AUTH_SLOT1_DIGEST
                size: 8
                offset: 3240
                ismubi: false
                isdigest: true
                iszer: false
                inv_default: 7544202290022723701
                iskeymgr_creator: false
                iskeymgr_owner: false
              }
            ]
            desc: Software managed SoC firmware authentication slot
            iskeymgr_creator: false
            iskeymgr_owner: false
            ignore_read_lock_in_rma: false
            size: 136
            offset: 3112
          }
          {
            name: SOC_FIRMWARE_AUTH_SLOT2
            variant: Unbuffered
            absorb: false
            secret: false
            sw_digest: true
            hw_digest: false
            write_lock: Digest
            read_lock: CSR
            key_sel: NoKey
            integrity: true
            bkout_type: false
            zeroizable: false
            items:
            [
              {
                name: SOC_FIRMWARE_AUTH_SLOT2_HASH
                size: 128
                desc: Hash of public key for SoC firmware (slot 2)
                isdigest: false
                iszer: false
                ismubi: false
                iskeymgr_creator: false
                iskeymgr_owner: false
                inv_default: 0
                offset: 3248
              }
              {
                name: SOC_FIRMWARE_AUTH_SLOT2_DIGEST
                size: 8
                offset: 3376
                ismubi: false
                isdigest: true
                iszer: false
                inv_default: 14656815325044117528
                iskeymgr_creator: false
                iskeymgr_owner: false
              }
            ]
            desc: Software managed SoC firmware authentication slot
            iskeymgr_creator: false
            iskeymgr_owner: false
            ignore_read_lock_in_rma: false
            size: 136
            offset: 3248
          }
          {
            name: SOC_FIRMWARE_AUTH_SLOT3
            variant: Unbuffered
            absorb: false
            secret: false
            sw_digest: true
            hw_digest: false
            write_lock: Digest
            read_lock: CSR
            key_sel: NoKey
            integrity: true
            bkout_type: false
            zeroizable: false
            items:
            [
              {
                name: SOC_FIRMWARE_AUTH_SLOT3_HASH
                size: 128
                desc: Hash of public key for SoC firmware (slot 3)
                isdigest: false
                iszer: false
                ismubi: false
                iskeymgr_creator: false
                iskeymgr_owner: false
                inv_default: 0
                offset: 3384
              }
              {
                name: SOC_FIRMWARE_AUTH_SLOT3_DIGEST
                size: 8
                offset: 3512
                ismubi: false
                isdigest: true
                iszer: false
                inv_default: 16898073465963608763
                iskeymgr_creator: false
                iskeymgr_owner: false
              }
            ]
            desc: Software managed SoC firmware authentication slot
            iskeymgr_creator: false
            iskeymgr_owner: false
            ignore_read_lock_in_rma: false
            size: 136
            offset: 3384
          }
          {
            name: EXT_NVM
            variant: Unbuffered
            absorb: false
            secret: false
            sw_digest: false
            hw_digest: false
            write_lock: None
            read_lock: CSR
            key_sel: NoKey
            integrity: false
            bkout_type: false
            zeroizable: false
            items:
            [
              {
                name: EXT_NVM_ANTIREPLAY_FRESHNESS_CNT
                size: 1024
                desc:
                  '''
                  Fully SW managed partition
                  1 bit (double bit allocated for redundancy - i.e. 2 physical bits for every logical bit) per day
                  assuming 10 year product lifecycle, allocating 8192 bits of freshness protection.
                  Implemented as thermometer encoding. Redundant bit programming & logical OR-ing managed by
                  software. Cannot be ECC protected since different bits in a fuse row are programmed at different times.
                  '''
                isdigest: false
                iszer: false
                ismubi: false
                iskeymgr_creator: false
                iskeymgr_owner: false
                inv_default: 0
                offset: 3520
              }
            ]
            desc: Anti-replay protection Strike Counters partition.
            iskeymgr_creator: false
            iskeymgr_owner: false
            ignore_read_lock_in_rma: false
            size: 1024
            offset: 3520
          }
          {
            name: HW_CFG0
            variant: Buffered
            secret: false
            sw_digest: false
            hw_digest: true
            write_lock: Digest
            read_lock: None
            key_sel: NoKey
            integrity: true
            bkout_type: true
            zeroizable: false
            skip_sw_header: true
            items:
            [
              {
                name: DEVICE_ID
                size: 32
                inv_default: 84636775181865843423447751136542243067225345129144998513113609321933118751675
                isdigest: false
                iszer: false
                ismubi: false
                iskeymgr_creator: false
                iskeymgr_owner: false
                offset: 4544
              }
              {
                name: MANUF_STATE
                size: 32
                inv_default: 89960518397345998442210387957448911146016937697982416014732294109643662651482
                isdigest: false
                iszer: false
                ismubi: false
                iskeymgr_creator: false
                iskeymgr_owner: false
                offset: 4576
              }
              {
                name: HW_CFG0_DIGEST
                size: 8
                offset: 4608
                ismubi: false
                isdigest: true
                iszer: false
                inv_default: 8821601860276922949
                iskeymgr_creator: false
                iskeymgr_owner: false
              }
            ]
            desc:
              '''
              Hardware configuration 0 partition.
              This contains
              - DEVICE_ID: Unique device identifier.
              - MANUF_STATE: Vector for capturing the manufacturing status.
              '''
            absorb: false
            iskeymgr_creator: false
            iskeymgr_owner: false
            ignore_read_lock_in_rma: false
            size: 72
            offset: 4544
          }
          {
            name: HW_CFG1
            variant: Buffered
            secret: false
            sw_digest: false
            hw_digest: true
            write_lock: Digest
            read_lock: None
            key_sel: NoKey
            integrity: true
            bkout_type: true
            zeroizable: false
            skip_sw_header: true
            items:
            [
              {
                name: SEC_BOOT_DBG
                size: 4
                inv_default: 0
                desc:
                  '''
                  Multibit enable value for Secure Boot.
                  Encoding TBD
                  '''
                isdigest: false
                iszer: false
                ismubi: false
                iskeymgr_creator: false
                iskeymgr_owner: false
                offset: 4616
              }
              {
                name: EN_CSRNG_SW_APP_READ
                size: 1
                ismubi: true
                inv_default: 105
                desc:
                  '''
                  Enablement of CSRNG software application interface. A
                  kMultiBitBool8True value enables, while all other values
                  disable. Enablement is required to extract output from
                  CSRNG via software.
                  '''
                isdigest: false
                iszer: false
                iskeymgr_creator: false
                iskeymgr_owner: false
                offset: 4620
              }
              {
                name: EN_SRAM_IFETCH
                size: 1
                ismubi: true
                inv_default: 105
                isdigest: false
                iszer: false
                iskeymgr_creator: false
                iskeymgr_owner: false
                offset: 4621
              }
              {
                name: HW_CFG1_DIGEST
                size: 8
                offset: 4624
                ismubi: false
                isdigest: true
                iszer: false
                inv_default: 9673330360152269864
                iskeymgr_creator: false
                iskeymgr_owner: false
              }
            ]
            desc:
              '''
              Hardware configuration 1 partition.
              This contains
              EN_SRAM_IFETCH: Enable / disable execute from SRAM CSR switch.
              SOC_DBG_STATE: Multibit enable value for the SOC debug authorization.
              Note SOC_DBG_STATE will be written twice in a device lifetime. The
              values to be written are engineered in the same way as the LC_CTRL
              state encoding words: the ECC encoding remains valid even after
              writing the second value on top of the first.

              The constants can be found in the lc_ctrl_state_pkg.sv package.

              The programming order has to adhere to:

              SOC_DBG_RAW -> SOC_DBG_PRE_PROD -> SOC_DBG_PROD.
              '''
            absorb: false
            iskeymgr_creator: false
            iskeymgr_owner: false
            ignore_read_lock_in_rma: false
            size: 16
            offset: 4616
          }
          {
            name: SECRET0
            variant: Buffered
            secret: true
            sw_digest: false
            hw_digest: true
            write_lock: Digest
            read_lock: Digest
            ignore_read_lock_in_rma: true
            key_sel: Secret0Key
            integrity: true
            bkout_type: false
            zeroizable: true
            skip_sw_header: true
            items:
            [
              {
                name: TEST_UNLOCK_TOKEN
                inv_default: 191985393975828609903709283012653827085
                size: 16
                isdigest: false
                iszer: false
                ismubi: false
                iskeymgr_creator: false
                iskeymgr_owner: false
                offset: 4632
              }
              {
                name: TEST_EXIT_TOKEN
                inv_default: 8049454917427216925997827152549284667
                size: 16
                isdigest: false
                iszer: false
                ismubi: false
                iskeymgr_creator: false
                iskeymgr_owner: false
                offset: 4648
              }
              {
                name: SECRET0_DIGEST
                size: 8
                offset: 4664
                ismubi: false
                isdigest: true
                iszer: false
                inv_default: 10065874593229139721
                iskeymgr_creator: false
                iskeymgr_owner: false
              }
              {
                name: SECRET0_ZER
                size: 8
                offset: 4672
                ismubi: false
                isdigest: false
                iszer: true
                inv_default: 0
                iskeymgr_creator: false
                iskeymgr_owner: false
              }
            ]
            desc:
              '''
              Secret partition 0.
              This contains TEST lifecycle unlock tokens.
              '''
            absorb: false
            iskeymgr_creator: false
            iskeymgr_owner: false
            size: 48
            offset: 4632
          }
          {
            name: SECRET1
            variant: Buffered
            secret: true
            sw_digest: false
            hw_digest: true
            write_lock: Digest
            read_lock: Digest
            ignore_read_lock_in_rma: true
            key_sel: Secret1Key
            integrity: true
            bkout_type: false
            zeroizable: true
            skip_sw_header: true
            items:
            [
              {
                name: SRAM_DATA_KEY_SEED
                inv_default: 119626835793529483393158377097849370351
                size: 16
                isdigest: false
                iszer: false
                ismubi: false
                iskeymgr_creator: false
                iskeymgr_owner: false
                offset: 4680
              }
              {
                name: SECRET1_DIGEST
                size: 8
                offset: 4696
                ismubi: false
                isdigest: true
                iszer: false
                inv_default: 12446391818523284464
                iskeymgr_creator: false
                iskeymgr_owner: false
              }
              {
                name: SECRET1_ZER
                size: 8
                offset: 4704
                ismubi: false
                isdigest: false
                iszer: true
                inv_default: 0
                iskeymgr_creator: false
                iskeymgr_owner: false
              }
            ]
            desc:
              '''
              Secret partition 1.
              This contains the SRAM scrambling key seed.
              '''
            absorb: false
            iskeymgr_creator: false
            iskeymgr_owner: false
            size: 32
            offset: 4680
          }
          {
            name: SECRET2
            variant: Buffered
            secret: true
            sw_digest: false
            hw_digest: true
            write_lock: Digest
            read_lock: Digest
            ignore_read_lock_in_rma: true
            key_sel: Secret2Key
            integrity: true
            bkout_type: false
            zeroizable: true
            skip_sw_header: true
            items:
            [
              {
                name: RMA_TOKEN
                inv_default: 257151471457813701810792034009910885873
                size: 16
                isdigest: false
                iszer: false
                ismubi: false
                iskeymgr_creator: false
                iskeymgr_owner: false
                offset: 4712
              }
              {
                name: CREATOR_ROOT_KEY_SHARE0
                inv_default: 58428367318477997995158430436185008200278041856729653820014384131744449381794
                size: 32
                iskeymgr_creator: true
                isdigest: false
                iszer: false
                ismubi: false
                iskeymgr_owner: false
                offset: 4728
              }
              {
                name: CREATOR_ROOT_KEY_SHARE1
                inv_default: 81109909720667310531206694470923378649726943238131960830210841988782597012480
                size: 32
                iskeymgr_creator: true
                isdigest: false
                iszer: false
                ismubi: false
                iskeymgr_owner: false
                offset: 4760
              }
              {
                name: CREATOR_SEED
                inv_default: 63999019030607151289909366880942569362330468042440373196189507388017079630937
                size: 32
                iskeymgr_creator: true
                isdigest: false
                iszer: false
                ismubi: false
                iskeymgr_owner: false
                offset: 4792
              }
              {
                name: SECRET2_DIGEST
                size: 8
                offset: 4824
                ismubi: false
                isdigest: true
                iszer: false
                inv_default: 16862586926326724172
                iskeymgr_creator: false
                iskeymgr_owner: false
              }
              {
                name: SECRET2_ZER
                size: 8
                offset: 4832
                ismubi: false
                isdigest: false
                iszer: true
                inv_default: 0
                iskeymgr_creator: false
                iskeymgr_owner: false
              }
            ]
            desc:
              '''
              Secret partition 2.
              This contains RMA unlock token, creator root key, and creator seed.
              '''
            absorb: false
            iskeymgr_creator: true
            iskeymgr_owner: false
            size: 128
            offset: 4712
          }
          {
            name: SECRET3
            variant: Buffered
            secret: true
            sw_digest: false
            hw_digest: true
            write_lock: Digest
            read_lock: Digest
            key_sel: Secret3Key
            integrity: true
            bkout_type: false
            zeroizable: true
            skip_sw_header: true
            items:
            [
              {
                name: OWNER_SEED
                inv_default: 10206999105613237488305124545664851698610302080045852370886952986780297145526
                size: 32
                iskeymgr_owner: true
                isdigest: false
                iszer: false
                ismubi: false
                iskeymgr_creator: false
                offset: 4840
              }
              {
                name: SECRET3_DIGEST
                size: 8
                offset: 4872
                ismubi: false
                isdigest: true
                iszer: false
                inv_default: 10297274993151818246
                iskeymgr_creator: false
                iskeymgr_owner: false
              }
              {
                name: SECRET3_ZER
                size: 8
                offset: 4880
                ismubi: false
                isdigest: false
                iszer: true
                inv_default: 0
                iskeymgr_creator: false
                iskeymgr_owner: false
              }
            ]
            desc:
              '''
              Secret partition 3.
              This contains the owner seed.
              '''
            absorb: false
            iskeymgr_creator: false
            iskeymgr_owner: true
            ignore_read_lock_in_rma: false
            size: 48
            offset: 4840
          }
          {
            name: LIFE_CYCLE
            variant: LifeCycle
            secret: false
            sw_digest: false
            hw_digest: false
            write_lock: None
            read_lock: None
            key_sel: NoKey
            integrity: true
            bkout_type: false
            skip_sw_header: true
            items:
            [
              {
                name: LC_TRANSITION_CNT
                inv_default: 34765581757057702526568169959179506991796799849684129792408382543682161064351438550357191642801906499564079722040959
                size: 48
                isdigest: false
                iszer: false
                ismubi: false
                iskeymgr_creator: false
                iskeymgr_owner: false
                offset: 4888
              }
              {
                name: LC_STATE
                inv_default: 508406651299787982309904825443985373106236637081727939090585644961445206666689630393817246511712
                size: 40
                isdigest: false
                iszer: false
                ismubi: false
                iskeymgr_creator: false
                iskeymgr_owner: false
                offset: 4936
              }
            ]
            desc:
              '''
              Lifecycle partition.
              This contains lifecycle transition count and state. This partition
              cannot be locked since the life cycle state needs to advance to RMA
              in-field. Note that while this partition is not marked secret, it
              is not readable nor writeable via the DAI. Only the LC controller
              can access this partition, and even via the LC controller it is not
              possible to read the raw manufacturing life cycle state in encoded
              form, since that encoding is considered a netlist secret. The LC
              controller only exposes a decoded version of this state.
              '''
            absorb: false
            iskeymgr_creator: false
            iskeymgr_owner: false
            zeroizable: false
            ignore_read_lock_in_rma: false
            size: 88
            offset: 4888
          }
        ]
      }
    }
    {
      name: lc_ctrl
      type: lc_ctrl
      base_addrs:
      {
        regs:
        {
          hart: 0x40030000
        }
        dmi:
        {
          soc_dbg: 0x3000
        }
      }
      memory: {}
      param_list:
      [
        {
          name: RndCnstLcKeymgrDivInvalid
          desc: Diversification value used for all invalid life cycle states.
          type: lc_ctrl_pkg::lc_keymgr_div_t
          randcount: 128
          randtype: data
          name_top: RndCnstLcCtrlLcKeymgrDivInvalid
          default: 0x8f9052c4e410a914d67ca904568db527
          randwidth: 128
        }
        {
          name: RndCnstLcKeymgrDivTestUnlocked
          desc: Diversification value used for the TEST_UNLOCKED* life cycle states.
          type: lc_ctrl_pkg::lc_keymgr_div_t
          randcount: 128
          randtype: data
          name_top: RndCnstLcCtrlLcKeymgrDivTestUnlocked
          default: 0xebd7543a4689bd951b183cb8bf216f28
          randwidth: 128
        }
        {
          name: RndCnstLcKeymgrDivDev
          desc: Diversification value used for the DEV life cycle state.
          type: lc_ctrl_pkg::lc_keymgr_div_t
          randcount: 128
          randtype: data
          name_top: RndCnstLcCtrlLcKeymgrDivDev
          default: 0x4e65e1fde71df816c143c2575bd40de3
          randwidth: 128
        }
        {
          name: RndCnstLcKeymgrDivProduction
          desc: Diversification value used for the PROD/PROD_END life cycle states.
          type: lc_ctrl_pkg::lc_keymgr_div_t
          randcount: 128
          randtype: data
          name_top: RndCnstLcCtrlLcKeymgrDivProduction
          default: 0xe98a45ce844ae951afc889275ace5410
          randwidth: 128
        }
        {
          name: RndCnstLcKeymgrDivRma
          desc: Diversification value used for the RMA life cycle state.
          type: lc_ctrl_pkg::lc_keymgr_div_t
          randcount: 128
          randtype: data
          name_top: RndCnstLcCtrlLcKeymgrDivRma
          default: 0x4d8883c173c10dffac297ae0f92f3724
          randwidth: 128
        }
        {
          name: RndCnstInvalidTokens
          desc: Compile-time random bits used for invalid tokens in the token mux
          type: lc_ctrl_pkg::lc_token_mux_t
          randcount: 1024
          randtype: data
          name_top: RndCnstLcCtrlInvalidTokens
          default: 0xba10b3a0a91b5288a3bdcbdfd488fa3778ebfb419ec7f5469441634806d05790dff6a451253ddfd78e689fd16d99b84890c036f4e8d7c83b63acda019f8d7eda05d5a9dfbf0c3f8670e567e3d45248fcc97c078901cc43863aa87fa680492a054b140bd9e143dfc4b6dbeed1bf90abfb15626596d2efd423c911abc24e671612
          randwidth: 1024
        }
      ]
    }
    {
      name: aes
      type: aes
      base_addrs:
      {
        null:
        {
          hart: 0x40100000
        }
      }
      memory: {}
      param_list:
      [
        {
          name: RndCnstClearingLfsrSeed
          desc: Default seed of the PRNG used for register clearing.
          type: aes_pkg::clearing_lfsr_seed_t
          randcount: 64
          randtype: data
          name_top: RndCnstAesClearingLfsrSeed
          default: 0x54169bdb5c2840f0
          randwidth: 64
        }
        {
          name: RndCnstClearingLfsrPerm
          desc: Permutation applied to the LFSR of the PRNG used for clearing.
          type: aes_pkg::clearing_lfsr_perm_t
          randcount: 64
          randtype: perm
          name_top: RndCnstAesClearingLfsrPerm
          default: 0xb1c82df65532173323dcf9ef048d3576aa19ac45a29950d00182e935a446fbfbbaf381ca5f14f08526c227be4e91f7b6
          randwidth: 384
        }
        {
          name: RndCnstClearingSharePerm
          desc: Permutation applied to the clearing PRNG output for clearing the second share of registers.
          type: aes_pkg::clearing_lfsr_perm_t
          randcount: 64
          randtype: perm
          name_top: RndCnstAesClearingSharePerm
          default: 0x1bf4fe115c7a157f5cab8b5e03c4229b9d4a94f7e0b144612c19cca47af66d6bd9d2e372683cc84a3c02dc9624ee839d
          randwidth: 384
        }
        {
          name: RndCnstMaskingLfsrSeed
          desc: Default seed of the PRNG used for masking.
          type: aes_pkg::masking_lfsr_seed_t
          randcount: 288
          randtype: data
          name_top: RndCnstAesMaskingLfsrSeed
          default: 0xc05bd6f0c7f6aa48a202e6f5ef8f36e1f62ae9ecef2f4a7e1ec425eef897221a1b2c10a9
          randwidth: 288
        }
        {
          name: RndCnstMaskingLfsrPerm
          desc: Permutation applied to the output of the PRNG used for masking.
          type: aes_pkg::masking_lfsr_perm_t
          randcount: 160
          randtype: perm
          name_top: RndCnstAesMaskingLfsrPerm
          default: 0x1875008c5076883c8b3a8a17367f123b7b1c293e64440e796899639a0b482c4a676d605d1627011f1b0989332d6f9d522305719439465706829b3f618d0f10874373697d6b559196805c747c5b2259626620429f8e980440904c720702087025305493787e2f864f849c111e851a131403324e2b97316c0d3595812a1d263d37289e926e65244d5a49510c83382119472e5e157a53418f5645770a6a58345f4b
          randwidth: 1280
        }
      ]
    }
    {
      name: kmac
      type: kmac
      base_addrs:
      {
        null:
        {
          hart: 0x40120000
        }
      }
      memory: {}
      param_list:
      [
        {
          name: RndCnstLfsrSeed
          desc: Compile-time random data for PRNG default seed
          type: kmac_pkg::lfsr_seed_t
          randcount: 288
          randtype: data
          name_top: RndCnstKmacLfsrSeed
          default: 0x8ef4200f5081cd00fd38f1d47cc0c6103a3da67f7ef3a4fca904a297a4495b792d1fe05a
          randwidth: 288
        }
        {
          name: RndCnstLfsrPerm
          desc: Compile-time random permutation for PRNG output
          type: kmac_pkg::lfsr_perm_t
          randcount: 800
          randtype: perm
          name_top: RndCnstKmacLfsrPerm
          default: 0xa9a8666d63ae9167266611201a5b7290c6b2ea61dd827425a44194264cc431d549263626adb15b1b72310887179ca87b007bff14a64e9ad131a863894029c724a9f5c2116934a9f086a3595dfd49e3e75094be83bc166a75ac20618765a5c0dc03162b380597aada474e950325b3758554c2d63d4b7847423add98a221590b638790340939cb2601f4392ce80ecf259423994d85ea514a7b8e40017e14800e5b8665ac9c64b7155e556bb9640f8624a4d8b99d1a802e8ed08459cf407105882f90c21aea5f51c64c21e6c7b1aa38c3c09811249f872605f0d14e245715c0b42a309dc122b0442b113c317a0cfc6d70a3eddc3f9e92996ac0e2c9fd07c26d98251c144549222913405bb44108d9a339744def58f5693bdeb018f59251146ca37d4de908a96f1f1bdd8d5412f47cbb8d15c5b66b2695b29e5e41a6f931b85687b185f9912c4369ff4d5f23da02aa961ba1b43200846a795e22b8656012ee9c6d432792804e7594d5e676e070c6c5fe25c60d2a8ad80489c78e0f31630735af85424b959ec5977382a98ba1e9b2c14f923934329a208aec6e9768bb4cb05480a2eae77970eb229f6402c2c69e388c02bebe524ae5f616bbdfa4c92e62a0a6fafd6eaa85c4707a94ca1278a6a692806b075cc6615916a519045e2257e94af9695a09c6de9ea0d13aa76187fb1e74304adc746aa5cbd81a1f096ac110abb89b20d5303ce9c5d96f1a2563ca4fbca9b7bcbf4019f68e4083a324f6ca5010d0805c2aaf4065c420a3cc1b0c47416221130690f461d8498be3f66dba983becb75c2d58868d359ca84ec93284cc34cf4b1e83370b788833b88b4271910cd58fed77f1a79d8d062c6664a6e58e369500e965d9194f14d9b9a491986c7e004b40122d37c8702e9405e7072c5013c3a8308d26c46b9078bd9bd286588eae37b56b1b5395a1c812063544915949d7b9ae3fe7c6b5db53cec576f0a04422e104990f8b480f23e1240c402f2b099efc4eab6adda92b1157ced41f1b60d87d4fef16ed346a9ac6ac8c40aa489080c4922ae498a314e28a6182d57a7521b001f748c766c1b0a22ac3cb52cced686cd620264787a2197557e7718095bac108a0760e1daabebf11d55448598bcd491ce85cc1c51967791660fd173e89377c1e0557b50544ac6db5baec4ae04781f86886f6467e2d90e88ce3c7edab0d3304402774e119dd7779f65b19316f007edbf7dd450f1140f497b30c930884528340522635dc9a168a215cea40750c0a592c92a605db44f912a463657a1cd48af5b0a58c4552050ce88633133de33c1c5756207a3eb536db3af2dfa26828413c0c4398dcd369a55bf8b95cac67faae3d24e9cd05c042b876f8a007214c818821149490ae0cba1d3ba18dc3a85565618bce279c9c7
          randwidth: 8000
        }
        {
          name: RndCnstBufferLfsrSeed
          desc: Compile-time random data for PRNG buffer default seed
          type: kmac_pkg::buffer_lfsr_seed_t
          randcount: 800
          randtype: data
          name_top: RndCnstKmacBufferLfsrSeed
          default: 0x43e42270b728fdd7b08a5c4de78de5e44021dbc55fb9ad96c258a13bf0bbcc7048148a6496135f0654389c91bed1da22e0d5b24874c4e21928ed714e82f58ebba15d3ad54138a5a9c21c493b07c2bab173198bdff759a49cb9f6383b8609a1a3e9b32aca
          randwidth: 800
        }
        {
          name: RndCnstMsgPerm
          desc: Compile-time random permutation for LFSR Message output
          type: kmac_pkg::msg_perm_t
          randcount: 64
          randtype: perm
          name_top: RndCnstKmacMsgPerm
          default: 0xf68e15b45986934d992cc6b347aca37b1729baa0b01f73bc8815a16cd0fee605df2a5b1dff59ef4c825012b60fed4480
          randwidth: 384
        }
      ]
    }
    {
      name: otbn
      type: otbn
      base_addrs:
      {
        null:
        {
          hart: 0x40130000
        }
      }
      memory: {}
      param_list:
      [
        {
          name: RndCnstUrndPrngSeed
          desc: Default seed of the PRNG used for URND.
          type: otbn_pkg::urnd_prng_seed_t
          randcount: 288
          randtype: data
          name_top: RndCnstOtbnUrndPrngSeed
          default: 0x6172c7d04859ac5cfea1a64b0b0d05ad4d6e24a4bc3154c48126bfb28a4aefb7f20aa522
          randwidth: 288
        }
        {
          name: RndCnstBnMacUrndPerm
          desc: Compile-time random permutation for URND permutation in BN MAC.
          type: otbn_pkg::bn_mac_urnd_perm_t
          randcount: 256
          randtype: perm
          name_top: RndCnstOtbnBnMacUrndPerm
          default: 0x4d54849a1959bb3fbed1e5c024418f5ccc3cf9a622a3abcdd06f131f4bc4db614fa4666550b2568576b553fdcfe9749c3ed3ca80a2f775778aef2c2ebc38b8714a9991b97968733609059e0dbd0188a96cfcd6f1de2b32ebc7b77f45ad6ae4837e17219b4262bad528e6f058827cedea0b51a0723b8c52e0c2f8b6c13198b0c80767aee123344caf4e7ab1a56457b443f3dc201a5f1ccec6ee4729081eaa8944daffdd04601495cb2d86405d3d5b358102f212d8fb5a2a27d99333462fd46eec70b3033ae37b6d8d15f425f663c9acd20a0c37df18c5556b1b48a7bf0f16119f30788e9d8b69941dfad7c3875e0610960097f5a892493990a10e26e7e8e2fe7d
          randwidth: 2048
        }
        {
          name: RndCnstOtbnKey
          desc: Compile-time random reset value for IMem/DMem scrambling key.
          type: otp_ctrl_pkg::otbn_key_t
          randcount: 128
          randtype: data
          name_top: RndCnstOtbnOtbnKey
          default: 0x99bbdf6758ad8609a3095d167b010694
          randwidth: 128
        }
        {
          name: RndCnstOtbnNonce
          desc: Compile-time random reset value for IMem/DMem scrambling nonce.
          type: otp_ctrl_pkg::otbn_nonce_t
          randcount: 64
          randtype: data
          name_top: RndCnstOtbnOtbnNonce
          default: 0x83d2ff7167a7cbf9
          randwidth: 64
        }
      ]
    }
    {
      name: keymgr_dpe
      type: keymgr_dpe
      base_addrs:
      {
        null:
        {
          hart: 0x40140000
        }
      }
      memory: {}
      param_list:
      [
        {
          name: RndCnstLfsrSeed
          desc: Compile-time random bits for initial LFSR seed
          type: keymgr_pkg::lfsr_seed_t
          randcount: 64
          randtype: data
          name_top: RndCnstKeymgrDpeLfsrSeed
          default: 0x65a0e493d1ec1430
          randwidth: 64
        }
        {
          name: RndCnstLfsrPerm
          desc: Compile-time random permutation for LFSR output
          type: keymgr_pkg::lfsr_perm_t
          randcount: 64
          randtype: perm
          name_top: RndCnstKeymgrDpeLfsrPerm
          default: 0xe39527080c1c3b1b875fea2a4f420b2818091629906fdb1ebd1e8d63613365daed3e1952ddf1bb696c83d7f564f23a4c
          randwidth: 384
        }
        {
          name: RndCnstRandPerm
          desc: Compile-time random permutation for entropy used in share overriding
          type: keymgr_pkg::rand_perm_t
          randcount: 32
          randtype: perm
          name_top: RndCnstKeymgrDpeRandPerm
          default: 0x362f6e8a91731a15fe40dce19495e8d2b843d47e
          randwidth: 160
        }
        {
          name: RndCnstRevisionSeed
          desc: Compile-time random bits for revision seed
          type: keymgr_pkg::seed_t
          randcount: 256
          randtype: data
          name_top: RndCnstKeymgrDpeRevisionSeed
          default: 0x12485247595ec3b88dfbabbf99969ceab06917802cacd5762f634c14b36e8772
          randwidth: 256
        }
        {
          name: RndCnstSoftOutputSeed
          desc: Compile-time random bits for software generation seed
          type: keymgr_pkg::seed_t
          randcount: 256
          randtype: data
          name_top: RndCnstKeymgrDpeSoftOutputSeed
          default: 0xd67f9071b12dc05459b825dedefd386272a32c2db89e62f7c6c8310d9e08b3ff
          randwidth: 256
        }
        {
          name: RndCnstHardOutputSeed
          desc: Compile-time random bits for hardware generation seed
          type: keymgr_pkg::seed_t
          randcount: 256
          randtype: data
          name_top: RndCnstKeymgrDpeHardOutputSeed
          default: 0x3b8390db75ef94dac87b92fdfc150c6156628c4aa2cea5dba9f3180c48359728
          randwidth: 256
        }
        {
          name: RndCnstAesSeed
          desc: Compile-time random bits for generation seed when aes destination selected
          type: keymgr_pkg::seed_t
          randcount: 256
          randtype: data
          name_top: RndCnstKeymgrDpeAesSeed
          default: 0x441317c074f52708cd3dcbbddb73da690cc28200849d8ae10f42bf8ae019ca47
          randwidth: 256
        }
        {
          name: RndCnstKmacSeed
          desc: Compile-time random bits for generation seed when kmac destination selected
          type: keymgr_pkg::seed_t
          randcount: 256
          randtype: data
          name_top: RndCnstKeymgrDpeKmacSeed
          default: 0x440f207c421e5fcc4b4e3f26efd44f160aab7cfb11aa1cd334d52be33950bff9
          randwidth: 256
        }
        {
          name: RndCnstOtbnSeed
          desc: Compile-time random bits for generation seed when otbn destination selected
          type: keymgr_pkg::seed_t
          randcount: 256
          randtype: data
          name_top: RndCnstKeymgrDpeOtbnSeed
          default: 0xcb53080d35eff5128e07f55944d5951f2a38a5583629446361d8a4a42123e6b0
          randwidth: 256
        }
        {
          name: RndCnstNoneSeed
          desc: Compile-time random bits for generation seed when no destination selected
          type: keymgr_pkg::seed_t
          randcount: 256
          randtype: data
          name_top: RndCnstKeymgrDpeNoneSeed
          default: 0xb81867f5745f26856d0f9c3d99166e01edd5b8648771a4e58512eaa46ee7dc26
          randwidth: 256
        }
      ]
    }
    {
      name: csrng
      type: csrng
      base_addrs:
      {
        null:
        {
          hart: 0x40150000
        }
      }
      memory: {}
      param_list:
      [
        {
          name: RndCnstCsKeymgrDivNonProduction
          desc: Compile-time random bits for csrng state group diversification value
          type: csrng_pkg::cs_keymgr_div_t
          randcount: 384
          randtype: data
          name_top: RndCnstCsrngCsKeymgrDivNonProduction
          default: 0x9ce2f2f6e7b95767f1d20123ae962a003e30c2a8942f27c4ca21c6327fb8e7bf10c9ef8b9c0deb2418423faff41e7b4f
          randwidth: 384
        }
        {
          name: RndCnstCsKeymgrDivProduction
          desc: Compile-time random bits for csrng state group diversification value
          type: csrng_pkg::cs_keymgr_div_t
          randcount: 384
          randtype: data
          name_top: RndCnstCsrngCsKeymgrDivProduction
          default: 0xf4b0e69553d130a0407693de540219fc8494453ae7fd82ba5f8d8ff25c89c045cafb05418dfbe8d7fcbbefecd0724d14
          randwidth: 384
        }
      ]
    }
    {
      name: sram_ctrl_main
      type: sram_ctrl
      base_addrs:
      {
        regs:
        {
          hart: 0x40200000
        }
        ram:
        {
          hart: 0x10000000
        }
      }
      memory:
      {
        ram:
        {
          label: ram_main
          swaccess: rw
          data_intg_passthru: "true"
          exec: True
          byte_write: True
          size: 0x30000
        }
      }
      param_list:
      [
        {
          name: RndCnstSramKey
          desc: Compile-time random reset value for SRAM scrambling key.
          type: otp_ctrl_pkg::sram_key_t
          randcount: 128
          randtype: data
          name_top: RndCnstSramCtrlMainSramKey
          default: 0x5309f44aaff1872ff7e1093995149ec3
          randwidth: 128
        }
        {
          name: RndCnstSramNonce
          desc: Compile-time random reset value for SRAM scrambling nonce.
          type: otp_ctrl_pkg::sram_nonce_t
          randcount: 128
          randtype: data
          name_top: RndCnstSramCtrlMainSramNonce
          default: 0x1009401fd157bb84a905b2c5f9c73291
          randwidth: 128
        }
        {
          name: RndCnstLfsrSeed
          desc: Compile-time random bits for initial LFSR seed
          type: sram_ctrl_pkg::lfsr_seed_t
          randcount: 64
          randtype: data
          name_top: RndCnstSramCtrlMainLfsrSeed
          default: 0x6d3f0a01064f240e
          randwidth: 64
        }
        {
          name: RndCnstLfsrPerm
          desc: Compile-time random permutation for LFSR output
          type: sram_ctrl_pkg::lfsr_perm_t
          randcount: 64
          randtype: perm
          name_top: RndCnstSramCtrlMainLfsrPerm
          default: 0xf7101e6520d01f26d460425ad4f230f812863b75e373fceb9692f9e1dd24b6a57ada09ac3219d3bdff3bb8d0a2156468
          randwidth: 384
        }
      ]
    }
    {
      name: rom_ctrl
      type: rom_ctrl
      base_addrs:
      {
        rom:
        {
          hart: 0x00040000
        }
        regs:
        {
          hart: 0x40210000
        }
      }
      memory:
      {
        rom:
        {
          label: rom
          swaccess: ro
          data_intg_passthru: True
          exec: True
          byte_write: False
          size: 0x20000
        }
      }
      param_list:
      [
        {
          name: RndCnstScrNonce
          desc: Fixed nonce used for address / data scrambling
          type: bit [63:0]
          randcount: 64
          randtype: data
          name_top: RndCnstRomCtrlScrNonce
          default: 0xa6ac182db8d1a221
          randwidth: 64
        }
        {
          name: RndCnstScrKey
          desc: Randomised constant used as a scrambling key for ROM data
          type: bit [127:0]
          randcount: 128
          randtype: data
          name_top: RndCnstRomCtrlScrKey
          default: 0x875bffbd69423adca64da6e21f029892
          randwidth: 128
        }
      ]
    }
    {
      name: rv_core_ibex
      type: rv_core_ibex
      base_addrs:
      {
        cfg:
        {
          hart: 0x40220000
        }
      }
      memory: {}
      param_list:
      [
        {
          name: RndCnstLfsrSeed
          desc: Default seed of the PRNG used for random instructions.
          type: ibex_pkg::lfsr_seed_t
          randcount: 32
          randtype: data
          name_top: RndCnstRvCoreIbexLfsrSeed
          default: 0x3a2586b0
          randwidth: 32
        }
        {
          name: RndCnstLfsrPerm
          desc: Permutation applied to the LFSR of the PRNG used for random instructions.
          type: ibex_pkg::lfsr_perm_t
          randcount: 32
          randtype: perm
          name_top: RndCnstRvCoreIbexLfsrPerm
          default: 0x8516275cda0d73b4ff9669d92e967ec3d4044483
          randwidth: 160
        }
        {
          name: RndCnstIbexKey
          desc: Default icache scrambling key
          type: logic [ibex_pkg::SCRAMBLE_KEY_W-1:0]
          randcount: 128
          randtype: data
          name_top: RndCnstRvCoreIbexIbexKey
          default: 0xf1122beb15ea2fc002aae3aa4cdf001f
          randwidth: 128
        }
        {
          name: RndCnstIbexNonce
          desc: Default icache scrambling nonce
          type: logic [ibex_pkg::SCRAMBLE_NONCE_W-1:0]
          randcount: 64
          randtype: data
          name_top: RndCnstRvCoreIbexIbexNonce
          default: 0x7a0161dd19b6be6c
          randwidth: 64
        }
      ]
      template_type: rv_core_ibex
    }
    {
      name: alert_handler
      type: alert_handler
      base_addrs:
      {
        null:
        {
          hart: 0x41040000
        }
      }
      memory: {}
      param_list:
      [
        {
          name: RndCnstLfsrSeed
          desc: Compile-time random bits for initial LFSR seed
          type: alert_handler_pkg::lfsr_seed_t
          randcount: 32
          randtype: data
          name_top: RndCnstAlertHandlerLfsrSeed
          default: 0x3fa57aa9
          randwidth: 32
        }
        {
          name: RndCnstLfsrPerm
          desc: Compile-time random permutation for LFSR output
          type: alert_handler_pkg::lfsr_perm_t
          randcount: 32
          randtype: perm
          name_top: RndCnstAlertHandlerLfsrPerm
          default: 0x78d5d2f2c4ba7e0d0675a6d885ca0d3445ec1f2e
          randwidth: 160
        }
      ]
      template_type: alert_handler
    }
    {
      name: sram_ctrl_ret
      type: sram_ctrl
      base_addrs:
      {
        regs:
        {
          hart: 0x41050000
        }
        ram:
        {
          hart: 0x41100000
        }
      }
      memory:
      {
        ram:
        {
          label: ram_ret_aon
          swaccess: rw
          data_intg_passthru: "true"
          exec: True
          byte_write: True
          size: 0x2000
        }
      }
      param_list:
      [
        {
          name: RndCnstSramKey
          desc: Compile-time random reset value for SRAM scrambling key.
          type: otp_ctrl_pkg::sram_key_t
          randcount: 128
          randtype: data
          name_top: RndCnstSramCtrlRetSramKey
          default: 0x4275ffbb34d2938d19ce5dd7c307a18b
          randwidth: 128
        }
        {
          name: RndCnstSramNonce
          desc: Compile-time random reset value for SRAM scrambling nonce.
          type: otp_ctrl_pkg::sram_nonce_t
          randcount: 128
          randtype: data
          name_top: RndCnstSramCtrlRetSramNonce
          default: 0x42074925926c7f5f79b6c1cc7b7eac83
          randwidth: 128
        }
        {
          name: RndCnstLfsrSeed
          desc: Compile-time random bits for initial LFSR seed
          type: sram_ctrl_pkg::lfsr_seed_t
          randcount: 64
          randtype: data
          name_top: RndCnstSramCtrlRetLfsrSeed
          default: 0x1360785b797fc861
          randwidth: 64
        }
        {
          name: RndCnstLfsrPerm
          desc: Compile-time random permutation for LFSR output
          type: sram_ctrl_pkg::lfsr_perm_t
          randcount: 64
          randtype: perm
          name_top: RndCnstSramCtrlRetLfsrPerm
          default: 0xc35a79c81aa2155f613ac1fa37eb7cc447173dabfb9669f7d9919f2a4fd2ba0080af82633106d4796d0bce8613751203
          randwidth: 384
        }
      ]
    }
  ]
}
