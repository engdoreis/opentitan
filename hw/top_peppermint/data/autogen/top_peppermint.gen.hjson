// Copyright lowRISC contributors (OpenTitan project).
// Licensed under the Apache License, Version 2.0, see LICENSE for details.
// SPDX-License-Identifier: Apache-2.0
//
// ------------------- W A R N I N G: A U T O - G E N E R A T E D   C O D E !! -------------------//
// PLEASE DO NOT HAND-EDIT THIS FILE. IT HAS BEEN AUTO-GENERATED WITH THE FOLLOWING COMMAND:
// util/topgen.py -t hw/top_peppermint/data/top_peppermint.hjson
//                -o hw/top_peppermint/
{
  name: peppermint
  type: top
  datawidth: "32"
  ast: false
  power:
  {
    domains:
    [
      Aon
      Main
    ]
    default: Main
    wait_for_external_reset: false
    external_wakeups:
    [
      {
        name: wkup_req
        width: "1"
        module: soc
      }
    ]
    external_reset_requests:
    [
      {
        name: rst_req
        width: "1"
        module: soc
        desc: External reset request from the SoC
        enabled_after_reset: true
      }
    ]
    halt_ibex_via_rom_ctrl: false
  }
  inter_domain:
  {
    flat_clk_rst: true
    port_names:
    {
      clk_main_secure: clk_main
      clk_aon_secure: clk_aon
      rst_lc_main_main_n: rst_main_n
      rst_lc_main_shadowed_main_n: rst_main_shadowed_n
      rst_sys_main_n: rst_main_sys_n
      rst_lc_aon_main_n: rst_main_aon_n
    }
    signals:
    {
      Aon: []
      Main:
      [
        {
          kind: clk
          mgr: clkmgr
          name: clk_aon
          src: clkmgr_clocks.clk_aon_secure
          type: uni
          package: ""
          struct: logic
        }
        {
          kind: clk
          mgr: clkmgr
          name: clk_main
          src: clkmgr_clocks.clk_main_secure
          type: uni
          package: ""
          struct: logic
        }
        {
          kind: rst
          mgr: rstmgr
          name: rst_main_aon_n
          src: rstmgr_resets.rst_lc_aon_n[rstmgr_pkg::DomainMainSel]
          type: uni
          package: ""
          struct: logic
        }
        {
          kind: rst
          mgr: rstmgr
          name: rst_main_n
          src: rstmgr_resets.rst_lc_main_n[rstmgr_pkg::DomainMainSel]
          type: uni
          package: ""
          struct: logic
        }
        {
          kind: rst
          mgr: rstmgr
          name: rst_main_shadowed_n
          src: rstmgr_resets.rst_lc_main_shadowed_n[rstmgr_pkg::DomainMainSel]
          type: uni
          package: ""
          struct: logic
        }
        {
          kind: rst
          mgr: rstmgr
          name: rst_main_sys_n
          src: rstmgr_resets.rst_sys_n[rstmgr_pkg::DomainMainSel]
          type: uni
          package: ""
          struct: logic
        }
      ]
    }
  }
  unmanaged_clocks: {}
  clocks:
  {
    srcs:
    [
      {
        name: main
        aon: no
        freq: "400000000"
        ref: false
      }
      {
        name: aon
        aon: yes
        freq: "32768"
        ref: true
      }
    ]
    derived_srcs: []
    groups:
    [
      {
        name: ext
        src: ext
        sw_cg: no
        unique: no
        clocks:
        {
          clk_aon_i: aon
          clk_main_i: main
        }
      }
      {
        name: secure
        src: top
        sw_cg: no
        unique: no
        clocks:
        {
          clk_main_secure: main
          clk_aon_secure: aon
        }
      }
    ]
  }
  resets:
  {
    nodes:
    [
      {
        name: por_aon
        gen: false
        type: top
        domains:
        [
          Aon
          Main
        ]
        shadowed: false
        sw: false
        path: rst_por_aon_n
        clock: aon
      }
      {
        name: lc_src
        gen: false
        type: int
        domains: []
        shadowed: false
        sw: false
        path: ""
        clock: main
      }
      {
        name: sys_src
        gen: false
        type: int
        domains: []
        shadowed: false
        sw: false
        path: ""
        clock: main
      }
      {
        name: por_main
        gen: true
        type: top
        domains:
        [
          Aon
        ]
        shadowed: false
        sw: false
        path: rst_por_main_n
        parent: por_aon
        clock: main
      }
      {
        name: sys
        gen: true
        type: top
        domains:
        [
          Main
        ]
        shadowed: false
        sw: false
        path: rst_sys_n
        parent: sys_src
        clock: main
      }
      {
        name: lc_main
        gen: true
        type: top
        domains:
        [
          Aon
          Main
        ]
        shadowed: true
        sw: false
        path: rst_lc_main_n
        parent: lc_src
        clock: main
      }
      {
        name: lc_aon
        gen: true
        type: top
        domains:
        [
          Aon
          Main
        ]
        shadowed: true
        sw: false
        path: rst_lc_aon_n
        parent: lc_src
        clock: aon
      }
      {
        name: soc_cpu
        gen: true
        type: top
        domains:
        [
          Aon
        ]
        shadowed: false
        sw: true
        path: rst_soc_cpu_n
        parent: lc_src
        clock: aon
      }
    ]
  }
  reset_requests:
  {
    int:
    [
      {
        name: MainPwr
        desc: main power glitch reset request
        module: pwrmgr
      }
      {
        name: Esc
        desc: escalation reset request
        module: alert_handler
      }
    ]
    debug:
    [
      {
        name: Ndm
        desc: non-debug-module reset request
        module: rv_dm
      }
    ]
    peripheral:
    [
      {
        name: rst_req
        width: "1"
        module: soc
        desc: External reset request from the SoC
        enabled_after_reset: true
      }
    ]
  }
  num_cores: "1"
  default_plic: rv_plic
  default_alert_handler: alert_handler
  addr_spaces:
  [
    {
      name: hart
      desc: The main address space, shared between the CPU and DM
      subspaces:
      [
        {
          name: mmio
          desc:
            '''
            MMIO region excludes any memory that is separate from the module configuration
            space, i.e. ROM, main SRAM and mailbox SoC window are excluded but retention SRAM is included.
            '''
          nodes:
          [
            pwrmgr
            rstmgr
            clkmgr
            alert_handler
            rv_timer_aon
            sram_ctrl_ret_aon
            otp_ctrl.core
            otp_macro.prim
            lc_ctrl.regs
            rv_plic
            rv_dm.regs
            rom_ctrl.regs
            sram_ctrl_main.regs
            aes
            hmac
            kmac
            otbn
            keymgr_dpe
            csrng
            entropy_src
            edn0
            edn1
            rv_timer
            dma
            mbx0.core
            mbx1.core
          ]
        }
      ]
    }
    {
      name: soc_mbx
      desc: SoC address space for mailbox access
    }
    {
      name: soc_dbg
      desc: SoC address space for debug module interfaces
    }
  ]
  module:
  [
    {
      name: pwrmgr
      type: pwrmgr
      template_type: pwrmgr
      clock_srcs:
      {
        clk_i: aon
        clk_slow_i: aon
        clk_lc_i:
        {
          clock: main
          group: ext
        }
        clk_esc_i: aon
      }
      clock_group: ext
      reset_connections:
      {
        rst_ni:
        {
          name: por_aon
          domain: Aon
        }
        rst_main_ni:
        {
          name: por_aon
          domain: Main
        }
        rst_lc_ni:
        {
          name: lc_main
          domain: Aon
        }
        rst_esc_ni:
        {
          name: lc_aon
          domain: Aon
        }
        rst_slow_ni:
        {
          name: por_aon
          domain: Aon
        }
      }
      domain: Aon
      param_decl:
      {
        EscNumSeverities: AlertHandlerEscNumSeverities
        EscPingCountWidth: AlertHandlerEscPingCountWidth
      }
      attr: ipgen
      clock_connections:
      {
        clk_i: clk_aon_i
        clk_slow_i: clk_aon_i
        clk_lc_i: clk_main_i
        clk_esc_i: clk_aon_i
      }
      memory: {}
      param_list:
      [
        {
          name: EscNumSeverities
          desc: Number of escalation severities
          type: int
          default: AlertHandlerEscNumSeverities
          local: "false"
          expose: "false"
          name_top: PwrmgrEscNumSeverities
        }
        {
          name: EscPingCountWidth
          desc: Width of ping count for the escalation receiver
          type: int
          default: AlertHandlerEscPingCountWidth
          local: "false"
          expose: "false"
          name_top: PwrmgrEscPingCountWidth
        }
      ]
      inter_signal_list:
      [
        {
          name: pwr_ast
          struct: pwr_ast
          package: pwrmgr_pkg
          type: req_rsp
          act: req
          width: 1
          inst_name: pwrmgr
          default: ""
          top_signame: pwrmgr_pwr_ast
          index: -1
        }
        {
          name: pwr_rst
          struct: pwr_rst
          package: pwrmgr_pkg
          type: req_rsp
          act: req
          width: 1
          inst_name: pwrmgr
          default: ""
          end_idx: -1
          top_type: one-to-one
          top_signame: pwrmgr_pwr_rst
          index: -1
        }
        {
          name: pwr_clk
          struct: pwr_clk
          package: pwrmgr_pkg
          type: req_rsp
          act: req
          width: 1
          inst_name: pwrmgr
          default: ""
          end_idx: -1
          top_type: one-to-one
          top_signame: pwrmgr_pwr_clk
          index: -1
        }
        {
          name: pwr_otp
          struct: pwr_otp
          package: pwrmgr_pkg
          type: req_rsp
          act: req
          width: 1
          inst_name: pwrmgr
          default: ""
          end_idx: -1
          top_type: one-to-one
          top_signame: pwrmgr_pwr_otp
          index: -1
          external: true
          conn_type: false
        }
        {
          name: pwr_lc
          struct: pwr_lc
          package: lc_ctrl_pkg
          type: req_rsp
          act: req
          width: 1
          inst_name: pwrmgr
          default: ""
          end_idx: -1
          top_type: one-to-one
          top_signame: pwrmgr_pwr_lc
          index: -1
          external: true
          conn_type: false
        }
        {
          name: pwr_nvm
          struct: pwr_nvm
          package: pwrmgr_pkg
          type: uni
          act: rcv
          width: 1
          inst_name: pwrmgr
          index: -1
        }
        {
          name: esc_rst_tx
          struct: esc_tx
          package: prim_esc_pkg
          type: uni
          act: rcv
          width: 1
          inst_name: pwrmgr
          default: ""
          domain: Aon
          top_signame: alert_handler_esc_tx
          index: 3
        }
        {
          name: esc_rst_rx
          struct: esc_rx
          package: prim_esc_pkg
          type: uni
          act: req
          width: 1
          inst_name: pwrmgr
          default: ""
          domain: Aon
          top_signame: alert_handler_esc_rx
          index: 3
        }
        {
          name: pwr_cpu
          struct: cpu_pwrmgr
          package: rv_core_ibex_pkg
          type: uni
          act: rcv
          width: 1
          inst_name: pwrmgr
          default: ""
          domain: Aon
          top_signame: rv_core_ibex_pwrmgr
          index: -1
          external: true
          conn_type: false
        }
        {
          name: wakeups
          struct: logic
          type: uni
          act: rcv
          width: 1
          inst_name: pwrmgr
          default: ""
          package: ""
          external: true
          conn_type: false
          index: -1
          top_signame: wakeup_main
        }
        {
          name: rstreqs
          struct: logic
          type: uni
          act: rcv
          width: 1
          inst_name: pwrmgr
          default: ""
          package: ""
          end_idx: -1
          top_type: broadcast
          index: -1
        }
        {
          name: ndmreset_req
          struct: logic
          type: uni
          act: rcv
          width: 1
          inst_name: pwrmgr
          default: ""
          package: ""
          domain: Aon
          top_signame: rv_dm_ndmreset_req
          index: -1
          external: true
          conn_type: false
        }
        {
          name: strap
          struct: logic
          type: uni
          act: req
          width: 1
          inst_name: pwrmgr
          default: ""
          package: ""
          end_idx: -1
          top_type: broadcast
          top_signame: pwrmgr_strap
          index: -1
          external: true
          conn_type: false
        }
        {
          name: low_power
          struct: logic
          type: uni
          act: req
          width: 1
          inst_name: pwrmgr
          default: ""
          package: ""
          end_idx: -1
          top_type: broadcast
          index: -1
        }
        {
          name: rom_ctrl
          struct: pwrmgr_data
          package: rom_ctrl_pkg
          type: uni
          act: rcv
          width: 1
          default: rom_ctrl_pkg::PWRMGR_DATA_DEFAULT
          inst_name: pwrmgr
          end_idx: -1
          top_type: broadcast
          top_signame: pwrmgr_rom_ctrl
          index: -1
          external: true
          conn_type: false
        }
        {
          name: fetch_en
          struct: lc_tx
          package: lc_ctrl_pkg
          type: uni
          act: req
          width: 1
          inst_name: pwrmgr
          default: ""
          end_idx: -1
          top_type: broadcast
          top_signame: pwrmgr_fetch_en
          index: -1
          external: true
          conn_type: false
        }
        {
          name: lc_dft_en
          struct: lc_tx
          package: lc_ctrl_pkg
          type: uni
          act: rcv
          width: 1
          inst_name: pwrmgr
          default: ""
          domain: Aon
          top_signame: lc_ctrl_lc_dft_en
          index: -1
          external: true
          conn_type: false
        }
        {
          name: lc_hw_debug_en
          struct: lc_tx
          package: lc_ctrl_pkg
          type: uni
          act: rcv
          width: 1
          inst_name: pwrmgr
          default: ""
          domain: Aon
          top_signame: lc_ctrl_lc_hw_debug_en
          index: -1
          external: true
          conn_type: false
        }
        {
          name: sw_rst_req
          struct: mubi4
          package: prim_mubi_pkg
          type: uni
          act: rcv
          width: 1
          inst_name: pwrmgr
          default: ""
          domain: Aon
          top_signame: rstmgr_sw_rst_req
          index: -1
        }
        {
          name: tl
          struct: tl
          package: tlul_pkg
          type: req_rsp
          act: rsp
          width: 1
          inst_name: pwrmgr
          default: ""
          end_idx: -1
          top_type: one-to-one
          top_signame: pwrmgr_tl
          index: -1
        }
      ]
      base_addrs:
      {
        null:
        {
          hart: 0x40400000
        }
      }
      generate_dif: true
    }
    {
      name: rstmgr
      type: rstmgr
      template_type: rstmgr
      clock_srcs:
      {
        clk_i: aon
        clk_por_i: aon
        clk_aon_i: aon
        clk_main_i: main
      }
      clock_group: ext
      reset_connections:
      {
        rst_ni:
        {
          name: lc_aon
          domain: Aon
        }
        rst_por_ni:
        {
          name: por_aon
          domain: Aon
        }
      }
      domain: Aon
      param_decl:
      {
        SecCheck: "0"
      }
      attr: ipgen
      clock_connections:
      {
        clk_i: clk_aon_i
        clk_por_i: clk_aon_i
        clk_aon_i: clk_aon_i
        clk_main_i: clk_main_i
      }
      memory: {}
      param_list:
      [
        {
          name: SecCheck
          desc:
            '''
            When 1, enable rstmgr reset consistency checks.
            When 0, there are no consistency checks.
            '''
          type: bit
          default: "0"
          local: "false"
          expose: "true"
          name_top: SecRstmgrCheck
        }
        {
          name: SecMaxSyncDelay
          desc: The maximum synchronization delay for parent / child reset checks.
          type: int
          default: "2"
          local: "false"
          expose: "true"
          name_top: SecRstmgrMaxSyncDelay
        }
      ]
      inter_signal_list:
      [
        {
          name: por_n
          desc:
            '''
            Root power on reset signals from ast.
            There is one root reset signal for each core power domain.
            '''
          struct: logic
          type: uni
          act: rcv
          width: 2
          inst_name: rstmgr
          default: ""
          package: ""
          top_signame: rstmgr_por_n
          index: -1
        }
        {
          name: pwr
          desc:
            '''
            Reset request signals from power manager.
            Power manager can request for specific domains of the lc/sys reset tree to assert.
            '''
          struct: pwr_rst
          type: req_rsp
          act: rsp
          width: 1
          inst_name: rstmgr
          default: ""
          package: pwrmgr_pkg
          domain: Aon
          top_signame: pwrmgr_pwr_rst
          index: -1
        }
        {
          name: resets
          desc: Leaf resets fed to the system.
          struct: rstmgr_out
          package: rstmgr_pkg
          type: uni
          act: req
          width: 1
          inst_name: rstmgr
          default: ""
          top_signame: rstmgr_resets
          index: -1
        }
        {
          name: rst_en
          desc: Low-power-group outputs used by alert handler.
          struct: rstmgr_rst_en
          package: rstmgr_pkg
          type: uni
          act: req
          width: 1
          inst_name: rstmgr
          default: ""
          top_signame: rstmgr_rst_en
          index: -1
        }
        {
          name: alert_dump
          desc: Alert handler crash dump information.
          struct: alert_crashdump
          package: alert_handler_pkg
          type: uni
          act: rcv
          width: 1
          inst_name: rstmgr
          default: ""
          domain: Aon
          top_signame: alert_handler_crashdump
          index: -1
        }
        {
          name: cpu_dump
          desc: Main processing element crash dump information.
          struct: cpu_crash_dump
          package: rv_core_ibex_pkg
          type: uni
          act: rcv
          width: 1
          inst_name: rstmgr
          default: ""
          domain: Aon
          top_signame: rv_core_ibex_crash_dump
          index: -1
          external: true
          conn_type: false
        }
        {
          name: sw_rst_req
          desc: Software requested system reset to pwrmgr.
          struct: mubi4
          package: prim_mubi_pkg
          type: uni
          act: req
          width: 1
          inst_name: rstmgr
          default: ""
          end_idx: -1
          top_type: broadcast
          top_signame: rstmgr_sw_rst_req
          index: -1
        }
        {
          name: tl
          struct: tl
          package: tlul_pkg
          type: req_rsp
          act: rsp
          width: 1
          inst_name: rstmgr
          default: ""
          end_idx: -1
          top_type: one-to-one
          top_signame: rstmgr_tl
          index: -1
        }
      ]
      base_addrs:
      {
        null:
        {
          hart: 0x40410000
        }
      }
      generate_dif: true
    }
    {
      name: clkmgr
      type: clkmgr
      template_type: clkmgr
      clock_srcs:
      {
        clk_i: aon
        clk_main_i:
        {
          group: ext
          clock: main
        }
        clk_aon_i:
        {
          group: ext
          clock: aon
        }
      }
      clock_group: ext
      reset_connections:
      {
        rst_ni:
        {
          name: lc_aon
          domain: Aon
        }
        rst_aon_ni:
        {
          name: lc_aon
          domain: Aon
        }
        rst_main_ni:
        {
          name: lc_main
          domain: Aon
        }
        rst_root_ni:
        {
          name: por_aon
          domain: Aon
        }
        rst_root_main_ni:
        {
          name: por_main
          domain: Aon
        }
      }
      domain: Aon
      ipgen_params:
      {
        ext_clk_bypass: false
      }
      attr: ipgen
      clock_connections:
      {
        clk_i: clk_aon_i
        clk_main_i: clk_main_i
        clk_aon_i: clk_aon_i
      }
      param_decl: {}
      memory: {}
      param_list: []
      inter_signal_list:
      [
        {
          name: clocks
          struct: clkmgr_out
          package: clkmgr_pkg
          type: uni
          act: req
          width: 1
          inst_name: clkmgr
          default: ""
          top_signame: clkmgr_clocks
          index: -1
        }
        {
          name: cg_en
          struct: clkmgr_cg_en
          package: clkmgr_pkg
          type: uni
          act: req
          width: 1
          inst_name: clkmgr
          default: ""
          top_signame: clkmgr_cg_en
          index: -1
        }
        {
          name: jitter_en
          struct: mubi4
          package: prim_mubi_pkg
          type: uni
          act: req
          width: 1
          inst_name: clkmgr
          index: -1
        }
        {
          name: pwr
          struct: pwr_clk
          type: req_rsp
          act: rsp
          width: 1
          inst_name: clkmgr
          default: ""
          package: pwrmgr_pkg
          domain: Aon
          top_signame: pwrmgr_pwr_clk
          index: -1
        }
        {
          name: idle
          struct: mubi4
          package: prim_mubi_pkg
          type: uni
          act: rcv
          width: 1
          default: prim_mubi_pkg::MuBi4False
          inst_name: clkmgr
          end_idx: -1
          top_type: broadcast
          index: -1
        }
        {
          name: tl
          struct: tl
          package: tlul_pkg
          type: req_rsp
          act: rsp
          width: 1
          inst_name: clkmgr
          default: ""
          end_idx: -1
          top_type: one-to-one
          top_signame: clkmgr_tl
          index: -1
        }
      ]
      base_addrs:
      {
        null:
        {
          hart: 0x40420000
        }
      }
      generate_dif: true
    }
    {
      name: alert_handler
      type: alert_handler
      template_type: alert_handler
      clock_srcs:
      {
        clk_i: aon
        clk_edn_i:
        {
          clock: main
          group: secure
        }
      }
      clock_group: ext
      reset_connections:
      {
        rst_ni:
        {
          name: lc_aon
          domain: Aon
        }
        rst_edn_ni:
        {
          name: lc_main
          domain: Main
        }
      }
      domain: Aon
      param_decl:
      {
        EscNumSeverities: "4"
        EscPingCountWidth: "16"
      }
      incoming_alert:
      [
        incoming_alerts_soc.hjson
      ]
      attr: ipgen
      clock_connections:
      {
        clk_i: clk_aon_i
        clk_edn_i: clkmgr_clocks.clk_main_secure
      }
      memory: {}
      param_list:
      [
        {
          name: EscNumSeverities
          desc: Number of escalation severities as regular parameter
          type: int
          default: "4"
          local: "false"
          expose: "true"
          name_top: AlertHandlerEscNumSeverities
        }
        {
          name: EscPingCountWidth
          desc: Width of ping counter as regular parameter
          type: int
          default: "16"
          local: "false"
          expose: "true"
          name_top: AlertHandlerEscPingCountWidth
        }
      ]
      inter_signal_list:
      [
        {
          name: crashdump
          struct: alert_crashdump
          package: alert_handler_pkg
          type: uni
          act: req
          width: 1
          inst_name: alert_handler
          default: ""
          end_idx: -1
          top_type: broadcast
          top_signame: alert_handler_crashdump
          index: -1
        }
        {
          name: edn
          struct: edn
          package: edn_pkg
          type: req_rsp
          act: req
          width: 1
          inst_name: alert_handler
          default: ""
          domain: Aon
          top_signame: edn0_edn
          index: -1
          external: true
          conn_type: false
        }
        {
          name: esc_rx
          struct: esc_rx
          package: prim_esc_pkg
          type: uni
          act: rcv
          width: 4
          inst_name: alert_handler
          default: ""
          end_idx: -1
          top_type: one-to-N
          top_signame: alert_handler_esc_rx
          index:
          [
            0
            1
            2
          ]
          external: true
          conn_type: true
        }
        {
          name: esc_tx
          struct: esc_tx
          package: prim_esc_pkg
          type: uni
          act: req
          width: 4
          inst_name: alert_handler
          default: ""
          end_idx: -1
          top_type: one-to-N
          top_signame: alert_handler_esc_tx
          index:
          [
            0
            1
            2
          ]
          external: true
          conn_type: true
        }
        {
          name: tl
          struct: tl
          package: tlul_pkg
          type: req_rsp
          act: rsp
          width: 1
          inst_name: alert_handler
          default: ""
          end_idx: -1
          top_type: one-to-one
          top_signame: alert_handler_tl
          index: -1
        }
      ]
      base_addrs:
      {
        null:
        {
          hart: 0x40450000
        }
      }
      generate_dif: true
    }
    {
      name: rv_timer_aon
      type: rv_timer
      clock_srcs:
      {
        clk_i: aon
      }
      clock_group: ext
      reset_connections:
      {
        rst_ni:
        {
          name: lc_aon
          domain: Aon
        }
      }
      domain: Aon
      clock_connections:
      {
        clk_i: clk_aon_i
      }
      param_decl: {}
      memory: {}
      param_list: []
      inter_signal_list:
      [
        {
          name: racl_policies
          desc:
            '''
            Incoming RACL policy vector from a racl_ctrl instance.
            The policy selection vector (parameter) selects the policy for each register.
            '''
          struct: racl_policy_vec
          package: top_racl_pkg
          type: uni
          act: rcv
          width: 1
          inst_name: rv_timer_aon
          index: -1
        }
        {
          name: racl_error
          desc: RACL error log information of this module.
          struct: racl_error_log
          package: top_racl_pkg
          type: uni
          act: req
          width: 1
          inst_name: rv_timer_aon
          index: -1
        }
        {
          name: tl
          struct: tl
          package: tlul_pkg
          type: req_rsp
          act: rsp
          width: 1
          inst_name: rv_timer_aon
          default: ""
          end_idx: -1
          top_type: one-to-one
          top_signame: rv_timer_aon_tl
          index: -1
        }
      ]
      base_addrs:
      {
        null:
        {
          hart: 0x40430000
        }
      }
      generate_dif: true
    }
    {
      name: sram_ctrl_ret_aon
      type: sram_ctrl
      clock_srcs:
      {
        clk_i: aon
        clk_otp_i: main
      }
      clock_group: ext
      reset_connections:
      {
        rst_ni:
        {
          name: lc_aon
          domain: Aon
        }
        rst_otp_ni:
        {
          name: lc_main
          domain: Main
        }
      }
      domain: Aon
      param_decl:
      {
        InstrExec: "0"
        InstSize: 8192
      }
      base_addrs:
      {
        regs:
        {
          hart: 0x40460000
        }
        ram:
        {
          hart: 0x40470000
        }
      }
      memory:
      {
        ram:
        {
          label: ram_ret_aon
          swaccess: rw
          data_intg_passthru: "true"
          exec: True
          byte_write: True
          size: 0x2000
        }
      }
      clock_connections:
      {
        clk_i: clk_aon_i
        clk_otp_i: clk_main_i
      }
      param_list:
      [
        {
          name: MemSizeRam
          desc: Memory size of the RAM (in bytes).
          type: int
          name_top: MemSizeSramCtrlRetAonRam
          default: 8192
        }
        {
          name: InstSize
          desc: Memory size of a single RAM tile (in bytes).
          type: int
          default: 8192
          local: "false"
          expose: "true"
          name_top: SramCtrlRetAonInstSize
        }
        {
          name: NumRamInst
          desc: Number of internal RAM instances. Must be the same as ceil(MemSizeRam / InstSize) .
          type: int
          default: 1
          local: "false"
          expose: "true"
          name_top: SramCtrlRetAonNumRamInst
        }
        {
          name: InstrExec
          desc: Support execution from SRAM
          type: bit
          default: "0"
          local: "false"
          expose: "true"
          name_top: SramCtrlRetAonInstrExec
        }
        {
          name: NumPrinceRoundsHalf
          desc: Number of PRINCE half rounds for the SRAM scrambling feature
          type: int
          default: "3"
          local: "false"
          expose: "true"
          name_top: SramCtrlRetAonNumPrinceRoundsHalf
        }
        {
          name: Outstanding
          desc: Number of outstanding TLUL transactions
          type: int
          default: "2"
          local: "true"
          expose: "true"
          name_top: SramCtrlRetAonOutstanding
        }
        {
          name: EccCorrection
          desc: Enable single-bit error correction and error logging
          type: bit
          default: "0"
          local: "false"
          expose: "true"
          name_top: SramCtrlRetAonEccCorrection
        }
      ]
      inter_signal_list:
      [
        {
          name: sram_otp_key
          struct: sram_otp_key
          package: otp_ctrl_pkg
          type: req_rsp
          act: req
          width: 1
          inst_name: sram_ctrl_ret_aon
          default: ""
          domain: Aon
          top_signame: otp_ctrl_sram_otp_key
          index: -1
          external: true
          conn_type: false
        }
        {
          name: ram_cfg
          struct: ram_1p_cfg
          package: prim_ram_1p_pkg
          type: req_rsp
          act: rsp
          width:
          {
            name: NumRamInst
            desc: Number of internal RAM instances. Must be the same as ceil(MemSizeRam / InstSize) .
            param_type: int
            unpacked_dimensions: null
            default: 1
            local: false
            expose: true
            name_top: SramCtrlRetAonNumRamInst
          }
          inst_name: sram_ctrl_ret_aon
          index: -1
        }
        {
          name: lc_escalate_en
          struct: lc_tx
          package: lc_ctrl_pkg
          type: uni
          act: rcv
          width: 1
          default: lc_ctrl_pkg::Off
          inst_name: sram_ctrl_ret_aon
          domain: Aon
          top_signame: lc_ctrl_lc_escalate_en
          index: -1
          external: true
          conn_type: false
        }
        {
          name: lc_hw_debug_en
          struct: lc_tx
          package: lc_ctrl_pkg
          type: uni
          act: rcv
          width: 1
          default: lc_ctrl_pkg::Off
          inst_name: sram_ctrl_ret_aon
          domain: Aon
          top_signame: lc_ctrl_lc_hw_debug_en
          index: -1
          external: true
          conn_type: false
        }
        {
          name: otp_en_sram_ifetch
          struct: mubi8
          package: prim_mubi_pkg
          type: uni
          act: rcv
          width: 1
          default: prim_mubi_pkg::MuBi8False
          inst_name: sram_ctrl_ret_aon
          index: -1
        }
        {
          name: racl_policies
          desc:
            '''
            Incoming RACL policy vector from a racl_ctrl instance.
            The policy selection vector (parameter) selects the policy for each register.
            '''
          struct: racl_policy_vec
          package: top_racl_pkg
          type: uni
          act: rcv
          width: 1
          inst_name: sram_ctrl_ret_aon
          index: -1
        }
        {
          name: racl_error
          desc: RACL error log information of this module.
          struct: racl_error_log
          package: top_racl_pkg
          type: uni
          act: req
          width: 1
          inst_name: sram_ctrl_ret_aon
          index: -1
        }
        {
          name: sram_rerror
          desc: SRAM read error indicating correctable and uncorrectable ECC errors.
          struct: sram_error_t
          package: sram_ctrl_pkg
          type: uni
          act: req
          width: 1
          inst_name: sram_ctrl_ret_aon
          index: -1
        }
        {
          name: regs_tl
          struct: tl
          package: tlul_pkg
          type: req_rsp
          act: rsp
          width: 1
          inst_name: sram_ctrl_ret_aon
          default: ""
          end_idx: -1
          top_type: one-to-one
          top_signame: sram_ctrl_ret_aon_regs_tl
          index: -1
        }
        {
          name: ram_tl
          struct: tl
          package: tlul_pkg
          type: req_rsp
          act: rsp
          width: 1
          inst_name: sram_ctrl_ret_aon
          default: ""
          end_idx: -1
          top_type: one-to-one
          top_signame: sram_ctrl_ret_aon_ram_tl
          index: -1
        }
      ]
      generate_dif: true
    }
    {
      name: otp_ctrl
      type: otp_ctrl
      template_type: otp_ctrl
      clock_srcs:
      {
        clk_i: main
        clk_edn_i: main
      }
      clock_group: secure
      reset_connections:
      {
        rst_ni:
        {
          name: lc_main
          domain: Main
        }
        rst_edn_ni:
        {
          name: lc_main
          domain: Main
        }
      }
      base_addrs:
      {
        core:
        {
          hart: 0x30130000
        }
      }
      attr: ipgen
      clock_connections:
      {
        clk_i: clk_main_i
        clk_edn_i: clk_main_i
      }
      param_decl: {}
      memory: {}
      param_list: []
      inter_signal_list:
      [
        {
          name: edn
          desc: Entropy request to the entropy distribution network for LFSR reseeding and ephemeral key derivation.
          struct: edn
          package: edn_pkg
          type: req_rsp
          act: req
          width: 1
          inst_name: otp_ctrl
          default: ""
          domain: Main
          top_signame: edn0_edn
          index: 1
        }
        {
          name: pwr_otp
          desc: Initialization request/acknowledge from/to power manager.
          struct: pwr_otp
          package: pwrmgr_pkg
          type: req_rsp
          act: rsp
          width: 1
          default: "'0"
          inst_name: otp_ctrl
          domain: Main
          top_signame: pwrmgr_pwr_otp
          index: -1
          external: true
          conn_type: false
        }
        {
          name: lc_otp_program
          desc: Life cycle state transition interface.
          struct: lc_otp_program
          package: otp_ctrl_pkg
          type: req_rsp
          act: rsp
          width: 1
          default: "'0"
          inst_name: otp_ctrl
          domain: Main
          top_signame: lc_ctrl_lc_otp_program
          index: -1
        }
        {
          name: otp_lc_data
          desc:
            '''
            Life cycle state output holding the current life cycle state,
            the value of the transition counter and the tokens needed for life cycle transitions.
            '''
          struct: otp_lc_data
          package: otp_ctrl_pkg
          type: uni
          act: req
          width: 1
          default: "'0"
          inst_name: otp_ctrl
          end_idx: -1
          top_type: broadcast
          top_signame: otp_ctrl_otp_lc_data
          index: -1
        }
        {
          name: lc_escalate_en
          desc:
            '''
            Life cycle escalation enable coming from life cycle controller.
            This signal moves all FSMs within OTP into the error state.
            '''
          struct: lc_tx
          package: lc_ctrl_pkg
          type: uni
          act: rcv
          width: 1
          default: lc_ctrl_pkg::Off
          inst_name: otp_ctrl
          domain: Main
          top_signame: lc_ctrl_lc_escalate_en
          index: -1
        }
        {
          name: lc_creator_seed_sw_rw_en
          desc:
            '''
            Provision enable qualifier coming from life cycle controller.
            This signal enables SW read / write access to the RMA_TOKEN and CREATOR_ROOT_KEY_SHARE0 and CREATOR_ROOT_KEY_SHARE1.
            '''
          struct: lc_tx
          package: lc_ctrl_pkg
          type: uni
          act: rcv
          width: 1
          default: lc_ctrl_pkg::Off
          inst_name: otp_ctrl
          domain: Main
          top_signame: lc_ctrl_lc_creator_seed_sw_rw_en
          index: -1
        }
        {
          name: lc_owner_seed_sw_rw_en
          desc:
            '''
            Provision enable qualifier coming from life cycle controller.
            This signal enables SW read / write access to the OWNER_SEED.
            '''
          struct: lc_tx
          package: lc_ctrl_pkg
          type: uni
          act: rcv
          width: 1
          default: lc_ctrl_pkg::Off
          inst_name: otp_ctrl
          domain: Main
          top_signame: lc_ctrl_lc_owner_seed_sw_rw_en
          index: -1
        }
        {
          name: lc_seed_hw_rd_en
          desc:
            '''
            Seed read enable coming from life cycle controller.
            This signal enables HW read access to the CREATOR_ROOT_KEY_SHARE0 and CREATOR_ROOT_KEY_SHARE1.
            '''
          struct: lc_tx
          package: lc_ctrl_pkg
          type: uni
          act: rcv
          width: 1
          default: lc_ctrl_pkg::Off
          inst_name: otp_ctrl
          domain: Main
          top_signame: lc_ctrl_lc_seed_hw_rd_en
          index: -1
        }
        {
          name: lc_rma_state
          desc:
            '''
            This signal states whether the current life cycle is RMA.
            It is used to enable SW read access to (read-locked) partitions in the RMA state.
            '''
          struct: lc_tx
          package: lc_ctrl_pkg
          type: uni
          act: rcv
          width: 1
          default: lc_ctrl_pkg::Off
          inst_name: otp_ctrl
          domain: Main
          top_signame: lc_ctrl_lc_rma_state
          index: -1
        }
        {
          name: lc_check_byp_en
          desc:
            '''
            Life cycle partition check bypass signal.
            This signal causes the life cycle partition to bypass consistency checks during life cycle state transitions in order to prevent spurious consistency check failures.
            '''
          struct: lc_tx
          package: lc_ctrl_pkg
          type: uni
          act: rcv
          width: 1
          default: lc_ctrl_pkg::Off
          inst_name: otp_ctrl
          domain: Main
          top_signame: lc_ctrl_lc_check_byp_en
          index: -1
        }
        {
          name: keymgr_creator_root_key
          desc: Key output to the key manager holding CREATOR_ROOT_KEY_SHARE0 and CREATOR_ROOT_KEY_SHARE1.
          struct: keymgr_dpe_creator_root_key
          package: keymgr_dpe_pkg
          type: uni
          act: req
          width: 1
          default: "'0"
          inst_name: otp_ctrl
          end_idx: -1
          top_type: broadcast
          top_signame: otp_ctrl_keymgr_creator_root_key
          index: -1
        }
        {
          name: keymgr_creator_seed
          desc: Creator seed output to the key manager
          struct: keymgr_dpe_creator_seed
          package: keymgr_dpe_pkg
          type: uni
          act: req
          width: 1
          default: "'0"
          inst_name: otp_ctrl
          end_idx: -1
          top_type: broadcast
          top_signame: otp_ctrl_keymgr_creator_seed
          index: -1
        }
        {
          name: keymgr_owner_seed
          desc: Owner seed output to the key manager
          struct: keymgr_dpe_owner_seed
          package: keymgr_dpe_pkg
          type: uni
          act: req
          width: 1
          default: "'0"
          inst_name: otp_ctrl
          end_idx: -1
          top_type: broadcast
          top_signame: otp_ctrl_keymgr_owner_seed
          index: -1
        }
        {
          name: sram_otp_key
          desc: Array with key derivation interfaces for SRAM scrambling devices.
          struct: sram_otp_key
          package: otp_ctrl_pkg
          type: req_rsp
          act: rsp
          width: 4
          default: "'0"
          inst_name: otp_ctrl
          end_idx: 3
          top_type: partial-one-to-N
          top_signame: otp_ctrl_sram_otp_key
          index: 1
          external: true
          conn_type: true
        }
        {
          name: otbn_otp_key
          desc: Key derivation interface for OTBN scrambling devices.
          struct: otbn_otp_key
          package: otp_ctrl_pkg
          type: req_rsp
          act: rsp
          width: 1
          default: "'0"
          inst_name: otp_ctrl
          end_idx: -1
          top_type: one-to-one
          top_signame: otp_ctrl_otbn_otp_key
          index: -1
        }
        {
          name: otp_broadcast
          desc: Output of the HW partitions with breakout data types.
          struct: otp_broadcast
          package: otp_ctrl_part_pkg
          type: uni
          act: req
          width: 1
          default: "'0"
          inst_name: otp_ctrl
          top_signame: otp_ctrl_otp_broadcast
          index: -1
        }
        {
          name: otp_macro
          desc: Data interface for the OTP macro.
          struct: otp_ctrl_macro
          package: otp_ctrl_macro_pkg
          type: req_rsp
          act: req
          width: 1
          default: "'0"
          inst_name: otp_ctrl
          end_idx: -1
          top_type: one-to-one
          top_signame: otp_ctrl_otp_macro
          index: -1
        }
        {
          name: core_tl
          struct: tl
          package: tlul_pkg
          type: req_rsp
          act: rsp
          width: 1
          inst_name: otp_ctrl
          default: ""
          end_idx: -1
          top_type: one-to-one
          top_signame: otp_ctrl_core_tl
          index: -1
        }
      ]
      generate_dif: true
      domain: Main
    }
    {
      name: otp_macro
      type: otp_macro
      clock_srcs:
      {
        clk_i: main
      }
      clock_group: secure
      reset_connections:
      {
        rst_ni:
        {
          name: lc_main
          domain: Main
        }
      }
      base_addrs:
      {
        prim:
        {
          hart: 0x30140000
        }
      }
      param_decl:
      {
        Width: otp_ctrl_macro_pkg::OtpWidth
        Depth: otp_ctrl_macro_pkg::OtpDepth
        SizeWidth: otp_ctrl_macro_pkg::OtpSizeWidth
        VendorTestOffset: otp_ctrl_reg_pkg::VendorTestOffset
        VendorTestSize: otp_ctrl_reg_pkg::VendorTestSize
      }
      clock_connections:
      {
        clk_i: clk_main_i
      }
      memory: {}
      param_list:
      [
        {
          name: Width
          desc: Size of storage words in bits
          type: int
          default: otp_ctrl_macro_pkg::OtpWidth
          local: "false"
          expose: "false"
          name_top: OtpMacroWidth
        }
        {
          name: Depth
          desc: Number of words
          type: int
          default: otp_ctrl_macro_pkg::OtpDepth
          local: "false"
          expose: "false"
          name_top: OtpMacroDepth
        }
        {
          name: SizeWidth
          desc: Number of words transferred per access
          type: int
          default: otp_ctrl_macro_pkg::OtpSizeWidth
          local: "false"
          expose: "false"
          name_top: OtpMacroSizeWidth
        }
        {
          name: MemInitFile
          desc: ""
          type: ""
          default: '''""'''
          local: "false"
          expose: "true"
          name_top: OtpMacroMemInitFile
        }
        {
          name: VendorTestOffset
          desc: ""
          type: int
          default: otp_ctrl_reg_pkg::VendorTestOffset
          local: "false"
          expose: "false"
          name_top: OtpMacroVendorTestOffset
        }
        {
          name: VendorTestSize
          desc: ""
          type: int
          default: otp_ctrl_reg_pkg::VendorTestSize
          local: "false"
          expose: "false"
          name_top: OtpMacroVendorTestSize
        }
      ]
      inter_signal_list:
      [
        {
          name: obs_ctrl
          desc: AST observability control signals.
          struct: ast_obs_ctrl
          package: ast_pkg
          type: uni
          act: rcv
          width: 1
          inst_name: otp_macro
          index: -1
        }
        {
          name: otp_obs
          desc: AST observability bus.
          struct: logic
          type: uni
          act: req
          width: 8
          inst_name: otp_macro
          index: -1
        }
        {
          name: pwr_seq
          desc: Power sequencing signals to AST (VDD domain).
          struct: pwr_seq
          package: otp_macro_pkg
          type: uni
          act: req
          width: 1
          default: "'0"
          inst_name: otp_macro
          index: -1
        }
        {
          name: pwr_seq_h
          desc: Power sequencing signals coming from AST (VCC domain).
          struct: pwr_seq
          package: otp_macro_pkg
          type: uni
          act: rcv
          width: 1
          default: "'0"
          inst_name: otp_macro
          index: -1
        }
        {
          name: ext_voltage_h
          struct: ""
          type: io
          act: none
          width: 1
          default: "'0"
          inst_name: otp_macro
          index: -1
        }
        {
          name: lc_dft_en
          desc:
            '''
            Test enable qualifier coming from life cycle controller.
            This signals enables the TL-UL access port.
            '''
          struct: lc_tx
          package: lc_ctrl_pkg
          type: uni
          act: rcv
          width: 1
          default: lc_ctrl_pkg::Off
          inst_name: otp_macro
          domain: Main
          top_signame: lc_ctrl_lc_dft_en
          index: -1
        }
        {
          name: test
          desc: Vendor test control signals from/to the life cycle TAP.
          struct: otp_test
          package: otp_macro_pkg
          type: req_rsp
          act: rsp
          width: 1
          default: "'0"
          inst_name: otp_macro
          domain: Main
          top_signame: lc_ctrl_lc_otp_vendor_test
          index: -1
        }
        {
          name: otp
          desc: Data interface for the OTP macro.
          struct: otp_ctrl_macro
          package: otp_ctrl_macro_pkg
          type: req_rsp
          act: rsp
          width: 1
          default: "'0"
          inst_name: otp_macro
          domain: Main
          top_signame: otp_ctrl_otp_macro
          index: -1
        }
        {
          name: cfg
          struct: otp_cfg
          package: otp_macro_pkg
          type: uni
          act: rcv
          width: 1
          default: "'0"
          inst_name: otp_macro
          index: -1
        }
        {
          name: cfg_rsp
          struct: otp_cfg_rsp
          package: otp_macro_pkg
          type: uni
          act: req
          width: 1
          default: "'0"
          inst_name: otp_macro
          index: -1
        }
        {
          name: racl_policies
          desc:
            '''
            Incoming RACL policy vector from a racl_ctrl instance.
            The policy selection vector (parameter) selects the policy for each register.
            '''
          struct: racl_policy_vec
          package: top_racl_pkg
          type: uni
          act: rcv
          width: 1
          inst_name: otp_macro
          index: -1
        }
        {
          name: racl_error
          desc: RACL error log information of this module.
          struct: racl_error_log
          package: top_racl_pkg
          type: uni
          act: req
          width: 1
          inst_name: otp_macro
          index: -1
        }
        {
          name: prim_tl
          struct: tl
          package: tlul_pkg
          type: req_rsp
          act: rsp
          width: 1
          inst_name: otp_macro
          default: ""
          end_idx: -1
          top_type: one-to-one
          top_signame: otp_macro_prim_tl
          index: -1
        }
      ]
      generate_dif: true
      domain: Main
    }
    {
      name: lc_ctrl
      type: lc_ctrl
      clock_srcs:
      {
        clk_i: main
        clk_kmac_i: main
      }
      clock_group: secure
      reset_connections:
      {
        rst_ni:
        {
          name: lc_main
          domain: Main
        }
        rst_kmac_ni:
        {
          name: lc_main
          domain: Main
        }
      }
      base_addrs:
      {
        regs:
        {
          hart: 0x30150000
        }
        dmi:
        {
          soc_dbg: 0x3000
        }
      }
      param_decl:
      {
        SecVolatileRawUnlockEn: "0"
        SiliconCreatorId: 16'h 4003
        ProductId: 16'h 4100
        RevisionId: 8'h 01
        IdcodeValue: 32'h0000_0001
        UseDmiInterface: "1"
        NumRmaAckSigs: "1"
        EscNumSeverities: AlertHandlerEscNumSeverities
        EscPingCountWidth: AlertHandlerEscPingCountWidth
      }
      clock_connections:
      {
        clk_i: clk_main_i
        clk_kmac_i: clk_main_i
      }
      memory: {}
      param_list:
      [
        {
          name: SecVolatileRawUnlockEn
          desc:
            '''
            Disable (0) or enable (1) volatile RAW UNLOCK capability.
            If enabled, it is possible to perform a volatile RAW -> TEST_UNLOCKED0 transition
            without programming the OTP. This is a useful fallback mode in case the OTP is
            not working correctly.

            IMPORTANT NOTE: This should only be used in test chips. The parameter must be set
            to 0 in production tapeouts since this weakens the security posture of the RAW
            UNLOCK mechanism.
            '''
          type: bit
          default: "0"
          local: "false"
          expose: "true"
          name_top: SecLcCtrlVolatileRawUnlockEn
        }
        {
          name: UseDmiInterface
          desc: When 1, a TLUL-based DMI interface is used. When 0, a JTAG TAP is used.
          type: bit
          default: "1"
          local: "false"
          expose: "true"
          name_top: LcCtrlUseDmiInterface
        }
        {
          name: SiliconCreatorId
          desc: Chip generation number.
          type: logic [15:0]
          default: 16'h 4003
          local: "false"
          expose: "true"
          name_top: LcCtrlSiliconCreatorId
        }
        {
          name: ProductId
          desc: Chip revision number.
          type: logic [15:0]
          default: 16'h 4100
          local: "false"
          expose: "true"
          name_top: LcCtrlProductId
        }
        {
          name: RevisionId
          desc: Chip revision number.
          type: logic [7:0]
          default: 8'h 01
          local: "false"
          expose: "true"
          name_top: LcCtrlRevisionId
        }
        {
          name: IdcodeValue
          desc: JTAG ID code.
          type: logic [31:0]
          default: 32'h0000_0001
          local: "false"
          expose: "true"
          name_top: LcCtrlIdcodeValue
        }
        {
          name: NumRmaAckSigs
          desc: Number of NVM RMA wiping response signals
          type: int
          default: "1"
          local: "true"
          expose: "true"
          name_top: LcCtrlNumRmaAckSigs
        }
        {
          name: EscNumSeverities
          desc: Number of escalation severities
          type: int
          default: AlertHandlerEscNumSeverities
          local: "false"
          expose: "false"
          name_top: LcCtrlEscNumSeverities
        }
        {
          name: EscPingCountWidth
          desc: Width of ping count for the escalation receiver
          type: int
          default: AlertHandlerEscPingCountWidth
          local: "false"
          expose: "false"
          name_top: LcCtrlEscPingCountWidth
        }
      ]
      inter_signal_list:
      [
        {
          name: jtag
          struct: jtag
          package: jtag_pkg
          type: req_rsp
          act: rsp
          width: 1
          inst_name: lc_ctrl
          index: -1
        }
        {
          name: esc_scrap_state0_tx
          struct: esc_tx
          package: prim_esc_pkg
          type: uni
          act: rcv
          width: 1
          inst_name: lc_ctrl
          default: ""
          domain: Main
          top_signame: alert_handler_esc_tx
          index: 1
          external: true
          conn_type: false
        }
        {
          name: esc_scrap_state0_rx
          struct: esc_rx
          package: prim_esc_pkg
          type: uni
          act: req
          width: 1
          inst_name: lc_ctrl
          default: ""
          domain: Main
          top_signame: alert_handler_esc_rx
          index: 1
          external: true
          conn_type: false
        }
        {
          name: esc_scrap_state1_tx
          struct: esc_tx
          package: prim_esc_pkg
          type: uni
          act: rcv
          width: 1
          inst_name: lc_ctrl
          default: ""
          domain: Main
          top_signame: alert_handler_esc_tx
          index: 2
          external: true
          conn_type: false
        }
        {
          name: esc_scrap_state1_rx
          struct: esc_rx
          package: prim_esc_pkg
          type: uni
          act: req
          width: 1
          inst_name: lc_ctrl
          default: ""
          domain: Main
          top_signame: alert_handler_esc_rx
          index: 2
          external: true
          conn_type: false
        }
        {
          name: pwr_lc
          struct: pwr_lc
          package: lc_ctrl_pkg
          type: req_rsp
          act: rsp
          width: 1
          inst_name: lc_ctrl
          default: ""
          domain: Main
          top_signame: pwrmgr_pwr_lc
          index: -1
          external: true
          conn_type: false
        }
        {
          name: lc_otp_vendor_test
          struct: otp_test
          package: otp_macro_pkg
          type: req_rsp
          act: req
          width: 1
          default: "'0"
          inst_name: lc_ctrl
          end_idx: -1
          top_type: one-to-one
          top_signame: lc_ctrl_lc_otp_vendor_test
          index: -1
        }
        {
          name: otp_lc_data
          struct: otp_lc_data
          package: otp_ctrl_pkg
          type: uni
          act: rcv
          width: 1
          default: otp_ctrl_pkg::OTP_LC_DATA_DEFAULT
          inst_name: lc_ctrl
          domain: Main
          top_signame: otp_ctrl_otp_lc_data
          index: -1
        }
        {
          name: lc_otp_program
          struct: lc_otp_program
          package: otp_ctrl_pkg
          type: req_rsp
          act: req
          width: 1
          default: "'0"
          inst_name: lc_ctrl
          end_idx: -1
          top_type: one-to-one
          top_signame: lc_ctrl_lc_otp_program
          index: -1
        }
        {
          name: kmac_data
          struct: app
          package: kmac_pkg
          type: req_rsp
          act: req
          width: 1
          default: "'0"
          inst_name: lc_ctrl
          domain: Main
          top_signame: kmac_app
          index: 1
        }
        {
          name: lc_init_done
          desc:
            '''
            A signal that is On after lifecycle initialization is done.
            This signal is On when lifecycle initialization is complete and life cycle controller broadcast signals are valid.
            '''
          struct: lc_tx
          package: lc_ctrl_pkg
          type: uni
          act: req
          width: 1
          default: lc_ctrl_pkg::Off
          inst_name: lc_ctrl
          end_idx: -1
          top_type: broadcast
          top_signame: lc_ctrl_lc_init_done
          index: -1
        }
        {
          name: lc_raw_test_rma
          struct: lc_tx
          package: lc_ctrl_pkg
          type: uni
          act: req
          width: 1
          default: lc_ctrl_pkg::Off
          inst_name: lc_ctrl
          end_idx: -1
          top_type: broadcast
          index: -1
        }
        {
          name: lc_dft_en
          struct: lc_tx
          package: lc_ctrl_pkg
          type: uni
          act: req
          width: 1
          default: lc_ctrl_pkg::Off
          inst_name: lc_ctrl
          end_idx: -1
          top_type: broadcast
          top_signame: lc_ctrl_lc_dft_en
          index: -1
          external: true
          conn_type: true
        }
        {
          name: lc_nvm_debug_en
          struct: lc_tx
          package: lc_ctrl_pkg
          type: uni
          act: req
          width: 1
          default: lc_ctrl_pkg::Off
          inst_name: lc_ctrl
          top_signame: lc_ctrl_lc_nvm_debug_en
          index: -1
        }
        {
          name: lc_hw_debug_clr
          desc:
            '''
            Clear HW debug functionality.
            This signal is On when `lc_hw_debug_en` turns Off outside a reset of `lc_ctrl`.
            Flops storing the value of `lc_hw_debug_en` (see below) must be cleared when this signal is On.
            '''
          struct: lc_tx
          package: lc_ctrl_pkg
          type: uni
          act: req
          width: 1
          default: lc_ctrl_pkg::Off
          inst_name: lc_ctrl
          end_idx: -1
          top_type: broadcast
          top_signame: lc_ctrl_lc_hw_debug_clr
          index: -1
        }
        {
          name: lc_hw_debug_en
          desc:
            '''
            Enable HW debug functionality; see `HW_DEBUG_EN` in the Theory of Operation doc for details.

            This signal is Off while lc_ctrl is in reset.
            In order to prevent a JTAG disconnect during non-debug-module (NDM) reset, this signal should be flopped outside the NDM reset domain.
            Such a flop must be cleared when `lc_hw_debug_clr` is On; see above.
            '''
          struct: lc_tx
          package: lc_ctrl_pkg
          type: uni
          act: req
          width: 1
          default: lc_ctrl_pkg::Off
          inst_name: lc_ctrl
          end_idx: -1
          top_type: broadcast
          top_signame: lc_ctrl_lc_hw_debug_en
          index: -1
          external: true
          conn_type: true
        }
        {
          name: lc_cpu_en
          struct: lc_tx
          package: lc_ctrl_pkg
          type: uni
          act: req
          width: 1
          default: lc_ctrl_pkg::Off
          inst_name: lc_ctrl
          end_idx: -1
          top_type: broadcast
          top_signame: lc_ctrl_lc_cpu_en
          index: -1
        }
        {
          name: lc_keymgr_en
          struct: lc_tx
          package: lc_ctrl_pkg
          type: uni
          act: req
          width: 1
          default: lc_ctrl_pkg::Off
          inst_name: lc_ctrl
          end_idx: -1
          top_type: broadcast
          top_signame: lc_ctrl_lc_keymgr_en
          index: -1
        }
        {
          name: lc_escalate_en
          struct: lc_tx
          package: lc_ctrl_pkg
          type: uni
          act: req
          width: 1
          default: lc_ctrl_pkg::Off
          inst_name: lc_ctrl
          end_idx: -1
          top_type: broadcast
          top_signame: lc_ctrl_lc_escalate_en
          index: -1
          external: true
          conn_type: true
        }
        {
          name: lc_clk_byp_req
          struct: lc_tx
          package: lc_ctrl_pkg
          type: uni
          act: req
          width: 1
          default: lc_ctrl_pkg::Off
          inst_name: lc_ctrl
          domain: Main
          top_signame: lc_ctrl_lc_clk_byp_ack
          index: -1
        }
        {
          name: lc_clk_byp_ack
          struct: lc_tx
          package: lc_ctrl_pkg
          type: uni
          act: rcv
          width: 1
          default: lc_ctrl_pkg::Off
          inst_name: lc_ctrl
          end_idx: -1
          top_type: broadcast
          top_signame: lc_ctrl_lc_clk_byp_ack
          index: -1
        }
        {
          name: lc_nvm_rma_req
          struct: lc_tx
          package: lc_ctrl_pkg
          type: uni
          act: req
          width: 1
          default: lc_ctrl_pkg::Off
          inst_name: lc_ctrl
          end_idx: -1
          top_type: broadcast
          top_signame: lc_ctrl_lc_nvm_rma_req
          index: -1
        }
        {
          name: lc_nvm_rma_ack
          struct: lc_tx
          package: lc_ctrl_pkg
          type: uni
          act: rcv
          width: 2
          default: lc_ctrl_pkg::On
          inst_name: lc_ctrl
          domain: Main
          top_signame: otbn_lc_rma_ack
          index: -1
        }
        {
          name: lc_nvm_rma_seed
          struct: lc_nvm_rma_seed
          package: lc_ctrl_pkg
          type: uni
          act: req
          width: 1
          default: "'0"
          inst_name: lc_ctrl
          index: -1
        }
        {
          name: lc_check_byp_en
          struct: lc_tx
          package: lc_ctrl_pkg
          type: uni
          act: req
          width: 1
          default: lc_ctrl_pkg::Off
          inst_name: lc_ctrl
          end_idx: -1
          top_type: broadcast
          top_signame: lc_ctrl_lc_check_byp_en
          index: -1
        }
        {
          name: lc_creator_seed_sw_rw_en
          struct: lc_tx
          package: lc_ctrl_pkg
          type: uni
          act: req
          width: 1
          default: lc_ctrl_pkg::Off
          inst_name: lc_ctrl
          end_idx: -1
          top_type: broadcast
          top_signame: lc_ctrl_lc_creator_seed_sw_rw_en
          index: -1
        }
        {
          name: lc_owner_seed_sw_rw_en
          struct: lc_tx
          package: lc_ctrl_pkg
          type: uni
          act: req
          width: 1
          default: lc_ctrl_pkg::Off
          inst_name: lc_ctrl
          end_idx: -1
          top_type: broadcast
          top_signame: lc_ctrl_lc_owner_seed_sw_rw_en
          index: -1
        }
        {
          name: lc_iso_part_sw_rd_en
          struct: lc_tx
          package: lc_ctrl_pkg
          type: uni
          act: req
          width: 1
          default: lc_ctrl_pkg::Off
          inst_name: lc_ctrl
          index: -1
        }
        {
          name: lc_iso_part_sw_wr_en
          struct: lc_tx
          package: lc_ctrl_pkg
          type: uni
          act: req
          width: 1
          default: lc_ctrl_pkg::Off
          inst_name: lc_ctrl
          index: -1
        }
        {
          name: lc_seed_hw_rd_en
          struct: lc_tx
          package: lc_ctrl_pkg
          type: uni
          act: req
          width: 1
          default: lc_ctrl_pkg::Off
          inst_name: lc_ctrl
          end_idx: -1
          top_type: broadcast
          top_signame: lc_ctrl_lc_seed_hw_rd_en
          index: -1
        }
        {
          name: lc_rma_state
          struct: lc_tx
          package: lc_ctrl_pkg
          type: uni
          act: req
          width: 1
          default: lc_ctrl_pkg::Off
          inst_name: lc_ctrl
          end_idx: -1
          top_type: broadcast
          top_signame: lc_ctrl_lc_rma_state
          index: -1
        }
        {
          name: lc_keymgr_div
          struct: lc_keymgr_div
          package: lc_ctrl_pkg
          type: uni
          act: req
          width: 1
          default: "'0"
          inst_name: lc_ctrl
          end_idx: -1
          top_type: broadcast
          top_signame: lc_ctrl_lc_keymgr_div
          index: -1
        }
        {
          name: otp_device_id
          struct: otp_device_id
          package: otp_ctrl_pkg
          type: uni
          act: rcv
          width: 1
          default: "'0"
          inst_name: lc_ctrl
          top_signame: lc_ctrl_otp_device_id
          index: -1
        }
        {
          name: otp_manuf_state
          struct: otp_manuf_state
          package: otp_ctrl_pkg
          type: uni
          act: rcv
          width: 1
          default: "'0"
          inst_name: lc_ctrl
          top_signame: lc_ctrl_otp_manuf_state
          index: -1
        }
        {
          name: hw_rev
          struct: lc_hw_rev
          package: lc_ctrl_pkg
          type: uni
          act: req
          width: 1
          default: "'0"
          inst_name: lc_ctrl
          index: -1
        }
        {
          name: strap_en_override
          desc:
            '''
            This signal transitions from 0 -> 1 by the lc_ctrl manager after volatile RAW_UNLOCK in order to re-sample the HW straps.
            The signal stays at 1 until reset.
            Note that this is only used in test chips when SecVolatileRawUnlockEn = 1.
            Otherwise this signal is tied off to 0.
            '''
          struct: logic
          type: uni
          act: req
          width: 1
          default: 1'b0
          inst_name: lc_ctrl
          package: ""
          end_idx: -1
          top_type: broadcast
          top_signame: lc_ctrl_strap_en_override
          index: -1
        }
        {
          name: regs_tl
          struct: tl
          package: tlul_pkg
          type: req_rsp
          act: rsp
          width: 1
          inst_name: lc_ctrl
          default: ""
          end_idx: -1
          top_type: one-to-one
          top_signame: lc_ctrl_regs_tl
          index: -1
        }
        {
          name: dmi_tl
          struct: tl
          package: tlul_pkg
          type: req_rsp
          act: rsp
          width: 1
          inst_name: lc_ctrl
          default: ""
          end_idx: -1
          top_type: one-to-one
          top_signame: lc_ctrl_dmi_tl
          index: -1
        }
      ]
      generate_dif: true
      domain: Main
    }
    {
      name: rv_dm
      type: rv_dm
      clock_srcs:
      {
        clk_i: main
        clk_lc_i: main
      }
      clock_group: secure
      reset_connections:
      {
        rst_ni:
        {
          name: sys
          domain: Main
        }
        rst_lc_ni:
        {
          name: lc_main
          domain: Main
        }
      }
      base_addrs:
      {
        mem:
        {
          hart: 0x00050000
        }
        regs:
        {
          hart: 0x21200000
        }
        dbg:
        {
          soc_dbg: 0x00000000
        }
      }
      param_decl:
      {
        IdcodeValue: 32'h0000_0001
        SecVolatileRawUnlockEn: "0"
        UseDmiInterface: "1"
      }
      generate_dif: false
      clock_connections:
      {
        clk_i: clk_main_i
        clk_lc_i: clk_main_i
      }
      memory: {}
      param_list:
      [
        {
          name: IdcodeValue
          desc: RISC-V debug module JTAG ID code.
          type: logic [31:0]
          default: 32'h0000_0001
          local: "false"
          expose: "true"
          name_top: RvDmIdcodeValue
        }
        {
          name: UseDmiInterface
          desc: When 1, a TLUL-based DMI interface is used. When 0, a JTAG TAP is used.
          type: bit
          default: "1"
          local: "false"
          expose: "true"
          name_top: RvDmUseDmiInterface
        }
        {
          name: SecVolatileRawUnlockEn
          desc:
            '''
            Disable (0) or enable (1) volatile RAW UNLOCK capability.
            If enabled, the strap_en_override_i input can be used to re-sample the straps at runtime.
            IMPORTANT NOTE: This should only be used in test chips. The parameter must be set
            to 0 in production tapeouts since this weakens the security posture of the RAW
            UNLOCK mechanism.
            '''
          type: bit
          default: "0"
          local: "false"
          expose: "true"
          name_top: SecRvDmVolatileRawUnlockEn
        }
        {
          name: TlulHostUserRsvdBits
          desc: TLUL user bits sent on outgoing transfers.
          type: logic [tlul_pkg::RsvdWidth-1:0]
          default: "'0"
          local: "false"
          expose: "true"
          name_top: RvDmTlulHostUserRsvdBits
        }
      ]
      inter_signal_list:
      [
        {
          name: next_dm_addr
          desc:
            '''
            32bit word address of the next debug module.
            Set to 0x0 if this is the last debug module in the chain.
            '''
          struct: next_dm_addr
          package: rv_dm_pkg
          type: uni
          act: rcv
          width: 1
          default: "'0"
          inst_name: rv_dm
          index: -1
        }
        {
          name: jtag
          desc: JTAG signals for the RISC-V TAP.
          struct: jtag
          package: jtag_pkg
          type: req_rsp
          act: rsp
          width: 1
          inst_name: rv_dm
          index: -1
        }
        {
          name: lc_init_done
          desc: Lifecycle initialization done signal coming from life cycle controller.
          struct: lc_tx
          package: lc_ctrl_pkg
          type: uni
          act: rcv
          width: 1
          default: lc_ctrl_pkg::Off
          inst_name: rv_dm
          domain: Main
          top_signame: lc_ctrl_lc_init_done
          index: -1
        }
        {
          name: lc_hw_debug_clr
          desc:
            '''
            Multibit life cycle hardware debug clear signal coming from life cycle controller,
            asserted when the hardware debug mechanism was enabled and gets disabled.
            '''
          struct: lc_tx
          package: lc_ctrl_pkg
          type: uni
          act: rcv
          width: 1
          default: lc_ctrl_pkg::Off
          inst_name: rv_dm
          domain: Main
          top_signame: lc_ctrl_lc_hw_debug_clr
          index: -1
        }
        {
          name: lc_hw_debug_en
          desc:
            '''
            Multibit life cycle hardware debug enable signal coming from life cycle controller,
            asserted when the hardware debug mechanisms are enabled in the system.
            '''
          struct: lc_tx
          package: lc_ctrl_pkg
          type: uni
          act: rcv
          width: 1
          default: lc_ctrl_pkg::Off
          inst_name: rv_dm
          domain: Main
          top_signame: lc_ctrl_lc_hw_debug_en
          index: -1
        }
        {
          name: lc_dft_en
          desc:
            '''
            Multibit life cycle hardware debug enable signal coming from life cycle controller,
            asserted when the DFT mechanisms are enabled in the system.
            '''
          struct: lc_tx
          package: lc_ctrl_pkg
          type: uni
          act: rcv
          width: 1
          default: lc_ctrl_pkg::Off
          inst_name: rv_dm
          domain: Main
          top_signame: lc_ctrl_lc_dft_en
          index: -1
        }
        {
          name: pinmux_hw_debug_en
          desc:
            '''
            Multibit life cycle hardware debug enable signal coming from pinmux.
            This is a latched version of the lc_hw_debug_en signal and is only used to
            gate the JTAG / TAP side of the RV_DM. It is used to keep a debug session live
            while the rest of the system undergoes an NDM reset.
            '''
          struct: lc_tx
          package: lc_ctrl_pkg
          type: uni
          act: rcv
          width: 1
          default: lc_ctrl_pkg::Off
          inst_name: rv_dm
          index: -1
        }
        {
          name: otp_dis_rv_dm_late_debug
          struct: mubi8
          package: prim_mubi_pkg
          type: uni
          act: rcv
          width: 1
          default: prim_mubi_pkg::MuBi8False
          inst_name: rv_dm
          top_signame: rv_dm_otp_dis_rv_dm_late_debug
          index: -1
        }
        {
          name: unavailable
          desc:
            '''
            This signal indicates to the debug module that the main processor is not available
            for debug (e.g. due to a low-power state).
            '''
          struct: logic
          type: uni
          act: rcv
          width: 1
          default: 1'b0
          inst_name: rv_dm
          index: -1
        }
        {
          name: ndmreset_req
          desc: Non-debug module reset request going to the system reset infrastructure.
          struct: logic
          type: uni
          act: req
          width: 1
          inst_name: rv_dm
          default: ""
          package: ""
          end_idx: -1
          top_type: broadcast
          top_signame: rv_dm_ndmreset_req
          index: -1
          external: true
          conn_type: false
        }
        {
          name: dmactive
          desc:
            '''
            This signal indicates whether the debug module is active and can be used to prevent
            power down of the core and bus-attached peripherals.
            '''
          struct: logic
          type: uni
          act: req
          width: 1
          inst_name: rv_dm
          index: -1
        }
        {
          name: debug_req
          desc: This is the debug request interrupt going to the main processor.
          struct: logic [rv_dm_reg_pkg::NrHarts-1:0]
          type: uni
          act: req
          width: 1
          inst_name: rv_dm
          default: ""
          package: ""
          end_idx: -1
          top_type: broadcast
          top_signame: rv_dm_debug_req
          index: -1
        }
        {
          name: lc_escalate_en
          desc:
            '''
            Escalation enable signal coming from life cycle controller, used for invalidating
            the latched lc_hw_debug_en state inside the strap sampling logic.
            '''
          struct: lc_tx
          package: lc_ctrl_pkg
          type: uni
          act: rcv
          width: 1
          default: lc_ctrl_pkg::Off
          inst_name: rv_dm
          domain: Main
          top_signame: lc_ctrl_lc_escalate_en
          index: -1
        }
        {
          name: lc_check_byp_en
          desc:
            '''
            Check bypass enable signal coming from life cycle controller, used for invalidating
            the latched lc_hw_debug_en state inside the strap sampling logic. This signal is asserted
            whenever the life cycle controller performs a life cycle transition. Its main use is
            to skip any background checks inside the life cycle partition of the OTP controller while
            a life cycle transition is in progress.
            '''
          struct: lc_tx
          package: lc_ctrl_pkg
          type: uni
          act: rcv
          width: 1
          default: lc_ctrl_pkg::Off
          inst_name: rv_dm
          domain: Main
          top_signame: lc_ctrl_lc_check_byp_en
          index: -1
        }
        {
          name: strap_en
          desc: This signal is pulsed high by the power manager after reset in order to sample the HW straps.
          struct: logic
          type: uni
          act: rcv
          width: 1
          default: 1'b0
          inst_name: rv_dm
          package: ""
          domain: Main
          top_signame: pwrmgr_strap
          index: -1
          external: true
          conn_type: false
        }
        {
          name: strap_en_override
          desc:
            '''
            This signal transitions from 0 -> 1 by the lc_ctrl manager after volatile RAW_UNLOCK in order to re-sample the HW straps.
            The signal must stay at 1 until reset.
            Note that this is only used in test chips when SecVolatileRawUnlockEn = 1.
            Otherwise this signal is unused.
            '''
          struct: logic
          type: uni
          act: rcv
          width: 1
          default: 1'b0
          inst_name: rv_dm
          package: ""
          domain: Main
          top_signame: lc_ctrl_strap_en_override
          index: -1
        }
        {
          name: racl_policies
          desc:
            '''
            Incoming RACL policy vector from a racl_ctrl instance.
            The policy selection vector (parameter) selects the policy for each register.
            '''
          struct: racl_policy_vec
          package: top_racl_pkg
          type: uni
          act: rcv
          width: 1
          inst_name: rv_dm
          index: -1
        }
        {
          name: racl_error
          desc: RACL error log information of this module.
          struct: racl_error_log
          package: top_racl_pkg
          type: uni
          act: req
          width: 1
          inst_name: rv_dm
          index: -1
        }
        {
          name: sba_tl_h
          struct: tl
          package: tlul_pkg
          type: req_rsp
          act: req
          width: 1
          inst_name: rv_dm
          default: ""
          domain: Main
          top_signame: main_tl_rv_dm__sba
          index: -1
        }
        {
          name: regs_tl_d
          struct: tl
          package: tlul_pkg
          type: req_rsp
          act: rsp
          width: 1
          inst_name: rv_dm
          default: ""
          end_idx: -1
          top_type: one-to-one
          top_signame: rv_dm_regs_tl_d
          index: -1
        }
        {
          name: mem_tl_d
          struct: tl
          package: tlul_pkg
          type: req_rsp
          act: rsp
          width: 1
          inst_name: rv_dm
          default: ""
          end_idx: -1
          top_type: one-to-one
          top_signame: rv_dm_mem_tl_d
          index: -1
        }
        {
          name: dbg_tl_d
          struct: tl
          package: tlul_pkg
          type: req_rsp
          act: rsp
          width: 1
          inst_name: rv_dm
          default: ""
          end_idx: -1
          top_type: one-to-one
          top_signame: rv_dm_dbg_tl_d
          index: -1
        }
      ]
      domain: Main
    }
    {
      name: rv_plic
      type: rv_plic
      template_type: rv_plic
      clock_srcs:
      {
        clk_i: main
      }
      clock_group: secure
      reset_connections:
      {
        rst_ni:
        {
          name: lc_main
          domain: Main
        }
      }
      attr: ipgen
      targets:
      [
        rv_core_ibex
      ]
      incoming_interrupt:
      [
        incoming_interrupts_soc.hjson
      ]
      clock_connections:
      {
        clk_i: clk_main_i
      }
      param_decl: {}
      memory: {}
      param_list: []
      inter_signal_list:
      [
        {
          name: irq
          struct: logic
          type: uni
          act: req
          width: 1
          inst_name: rv_plic
          default: ""
          package: ""
          end_idx: -1
          top_type: broadcast
          top_signame: rv_plic_irq
          index: -1
        }
        {
          name: irq_id
          struct: logic
          type: uni
          act: req
          width: 1
          inst_name: rv_plic
          index: -1
        }
        {
          name: msip
          struct: logic
          type: uni
          act: req
          width: 1
          inst_name: rv_plic
          default: ""
          package: ""
          end_idx: -1
          top_type: broadcast
          top_signame: rv_plic_msip
          index: -1
        }
        {
          name: tl
          struct: tl
          package: tlul_pkg
          type: req_rsp
          act: rsp
          width: 1
          inst_name: rv_plic
          default: ""
          end_idx: -1
          top_type: one-to-one
          top_signame: rv_plic_tl
          index: -1
        }
      ]
      base_addrs:
      {
        null:
        {
          hart: 0x28000000
        }
      }
      generate_dif: true
      domain: Main
    }
    {
      name: rv_timer
      type: rv_timer
      clock_srcs:
      {
        clk_i: main
      }
      clock_group: secure
      reset_connections:
      {
        rst_ni:
        {
          name: lc_main
          domain: Main
        }
      }
      clock_connections:
      {
        clk_i: clk_main_i
      }
      param_decl: {}
      memory: {}
      param_list: []
      inter_signal_list:
      [
        {
          name: racl_policies
          desc:
            '''
            Incoming RACL policy vector from a racl_ctrl instance.
            The policy selection vector (parameter) selects the policy for each register.
            '''
          struct: racl_policy_vec
          package: top_racl_pkg
          type: uni
          act: rcv
          width: 1
          inst_name: rv_timer
          index: -1
        }
        {
          name: racl_error
          desc: RACL error log information of this module.
          struct: racl_error_log
          package: top_racl_pkg
          type: uni
          act: req
          width: 1
          inst_name: rv_timer
          index: -1
        }
        {
          name: tl
          struct: tl
          package: tlul_pkg
          type: req_rsp
          act: rsp
          width: 1
          inst_name: rv_timer
          default: ""
          end_idx: -1
          top_type: one-to-one
          top_signame: rv_timer_tl
          index: -1
        }
      ]
      base_addrs:
      {
        null:
        {
          hart: 0x21190000
        }
      }
      generate_dif: true
      domain: Main
    }
    {
      name: aes
      type: aes
      clock_srcs:
      {
        clk_i: main
        clk_edn_i: main
      }
      clock_group: secure
      reset_connections:
      {
        rst_ni:
        {
          name: lc_main
          domain: Main
        }
        rst_edn_ni:
        {
          name: lc_main
          domain: Main
        }
      }
      param_decl:
      {
        AESGCMEnable: "1"
        SecMasking: "1"
        SecSBoxImpl: aes_pkg::SBoxImplDom
      }
      clock_connections:
      {
        clk_i: clk_main_i
        clk_edn_i: clk_main_i
      }
      memory: {}
      param_list:
      [
        {
          name: AES192Enable
          desc: Disable (0) or enable (1) support for 192-bit key lengths (AES-192).
          type: bit
          default: 1'b1
          local: "false"
          expose: "false"
          name_top: AesAES192Enable
        }
        {
          name: AESGCMEnable
          desc: Disable (0) or enable (1) support for Galois/Counter Mode (GCM) in hardware.
          type: bit
          default: "1"
          local: "false"
          expose: "true"
          name_top: AesAESGCMEnable
        }
        {
          name: SecMasking
          desc:
            '''
            Disable (0) or enable (1) first-order masking of the AES cipher core and the GHASH operation of GCM.
            Masking requires the use of a masked S-Box, see SecSBoxImpl parameter.
            '''
          type: bit
          default: "1"
          local: "false"
          expose: "true"
          name_top: SecAesMasking
        }
        {
          name: SecSBoxImpl
          desc: Selection of the S-Box implementation. See aes_pkg.sv.
          type: aes_pkg::sbox_impl_e
          default: aes_pkg::SBoxImplDom
          local: "false"
          expose: "true"
          name_top: SecAesSBoxImpl
        }
        {
          name: SecStartTriggerDelay
          desc:
            '''
            Manual start trigger delay, useful for SCA measurements.
            A value of e.g. 40 allows the processor to go into sleep before AES starts operation.
            '''
          type: int unsigned
          default: "0"
          local: "false"
          expose: "true"
          name_top: SecAesStartTriggerDelay
        }
        {
          name: SecAllowForcingMasks
          desc:
            '''
            Forbid (0) or allow (1) forcing the masking PRNG output to a constant value via FORCE_MASKS bit in the Auxiliary Control Register.
            Useful for SCA measurements.
            Meaningful only if masking is enabled.
            '''
          type: bit
          default: 1'b0
          local: "false"
          expose: "true"
          name_top: SecAesAllowForcingMasks
        }
        {
          name: SecSkipPRNGReseeding
          desc:
            '''
            Perform (0) or skip (1) PRNG reseeding requests, useful for SCA measurements only.
            The current SCA setup doesn't provide sufficient resources to implement the infrastructure required for PRNG reseeding (CSRNG, EDN).
            To enable SCA resistance evaluations, we need to skip reseeding requests on the SCA platform.
            '''
          type: bit
          default: 1'b0
          local: "false"
          expose: "true"
          name_top: SecAesSkipPRNGReseeding
        }
      ]
      inter_signal_list:
      [
        {
          name: idle
          struct: mubi4
          package: prim_mubi_pkg
          type: uni
          act: req
          width: 1
          inst_name: aes
          index: -1
        }
        {
          name: output_valid
          struct: logic
          type: uni
          act: req
          width: 1
          inst_name: aes
          index: -1
        }
        {
          name: input_ready
          struct: logic
          type: uni
          act: req
          width: 1
          inst_name: aes
          index: -1
        }
        {
          name: lc_escalate_en
          struct: lc_tx
          package: lc_ctrl_pkg
          type: uni
          act: rcv
          width: 1
          default: lc_ctrl_pkg::Off
          inst_name: aes
          domain: Main
          top_signame: lc_ctrl_lc_escalate_en
          index: -1
        }
        {
          name: edn
          struct: edn
          package: edn_pkg
          type: req_rsp
          act: req
          width: 1
          inst_name: aes
          default: ""
          domain: Main
          top_signame: edn0_edn
          index: 4
        }
        {
          name: keymgr_key
          struct: hw_key_req
          package: keymgr_pkg
          type: uni
          act: rcv
          width: 1
          inst_name: aes
          default: ""
          domain: Main
          top_signame: keymgr_dpe_aes_key
          index: -1
        }
        {
          name: tl
          struct: tl
          package: tlul_pkg
          type: req_rsp
          act: rsp
          width: 1
          inst_name: aes
          default: ""
          end_idx: -1
          top_type: one-to-one
          top_signame: aes_tl
          index: -1
        }
      ]
      base_addrs:
      {
        null:
        {
          hart: 0x21100000
        }
      }
      generate_dif: true
      domain: Main
    }
    {
      name: hmac
      type: hmac
      clock_srcs:
      {
        clk_i: main
      }
      clock_group: secure
      reset_connections:
      {
        rst_ni:
        {
          name: lc_main
          domain: Main
        }
      }
      clock_connections:
      {
        clk_i: clk_main_i
      }
      param_decl: {}
      memory: {}
      param_list: []
      inter_signal_list:
      [
        {
          name: idle
          struct: mubi4
          package: prim_mubi_pkg
          type: uni
          act: req
          width: 1
          inst_name: hmac
          index: -1
        }
        {
          name: tl
          struct: tl
          package: tlul_pkg
          type: req_rsp
          act: rsp
          width: 1
          inst_name: hmac
          default: ""
          end_idx: -1
          top_type: one-to-one
          top_signame: hmac_tl
          index: -1
        }
      ]
      base_addrs:
      {
        null:
        {
          hart: 0x21110000
        }
      }
      generate_dif: true
      domain: Main
    }
    {
      name: kmac
      type: kmac
      param_decl:
      {
        EnMasking: "1"
        NumAppIntf: 3
        AppCfg:
          '''
          '{kmac_pkg::AppCfgKeyMgr,
                  kmac_pkg::AppCfgLcCtrl,
                  kmac_pkg::AppCfgRomCtrl}
          '''
      }
      clock_srcs:
      {
        clk_i: main
        clk_edn_i: main
      }
      clock_group: secure
      reset_connections:
      {
        rst_ni:
        {
          name: lc_main
          domain: Main
        }
        rst_edn_ni:
        {
          name: lc_main
          domain: Main
        }
      }
      clock_connections:
      {
        clk_i: clk_main_i
        clk_edn_i: clk_main_i
      }
      memory: {}
      param_list:
      [
        {
          name: EnMasking
          desc: Disable(0) or enable(1) first-order masking of Keccak round.
          type: bit
          default: "1"
          local: "false"
          expose: "true"
          name_top: KmacEnMasking
        }
        {
          name: SwKeyMasked
          desc:
            '''
            Disable(0) or enable(1) software key masking in case masking is disabled (EnMasking == 0).
            If masking is enabled, this parameter has no effect.
            Mainly useful for software interface compatibility between the masked and unmasked design.
            Mostly relevant for SCA measurements.
            '''
          type: bit
          default: "0"
          local: "false"
          expose: "true"
          name_top: KmacSwKeyMasked
        }
        {
          name: SecCmdDelay
          desc:
            '''
            Command delay, useful for SCA measurements only.
            A value of e.g. 40 allows the processor to go into sleep before KMAC starts operation.
            If a value greater than 0 is chosen, software can pass two commands in series.
            The second command is buffered internally and will be presented to the hardware SecCmdDelay number of cycles after the first one.
            '''
          type: int
          default: "0"
          local: "false"
          expose: "true"
          name_top: SecKmacCmdDelay
        }
        {
          name: SecIdleAcceptSwMsg
          desc:
            '''
            If enabled (1), software writes to the message FIFO before having received a START command are not ignored.
            Disabled (0) by default.
            Useful for SCA measurements only.
            '''
          type: bit
          default: "0"
          local: "false"
          expose: "true"
          name_top: SecKmacIdleAcceptSwMsg
        }
        {
          name: NumAppIntf
          desc: Number of application interfaces
          type: int
          default: 3
          local: "false"
          expose: "true"
          name_top: KmacNumAppIntf
        }
        {
          name: AppCfg
          desc:
            '''
            Application interface configuration.
            Top-level connection to the application interface must follow this definition.
            '''
          type: kmac_pkg::app_config_t
          unpacked_dimensions: "[KmacNumAppIntf]"
          default:
            '''
            '{kmac_pkg::AppCfgKeyMgr,
                    kmac_pkg::AppCfgLcCtrl,
                    kmac_pkg::AppCfgRomCtrl}
            '''
          local: "false"
          expose: "true"
          name_top: KmacAppCfg
        }
      ]
      inter_signal_list:
      [
        {
          name: keymgr_key
          struct: hw_key_req
          package: keymgr_pkg
          type: uni
          act: rcv
          width: 1
          inst_name: kmac
          default: ""
          domain: Main
          top_signame: keymgr_dpe_kmac_key
          index: -1
        }
        {
          name: app
          struct: app
          package: kmac_pkg
          type: req_rsp
          act: rsp
          width:
          {
            name: NumAppIntf
            desc: Number of application interfaces
            param_type: int
            unpacked_dimensions: null
            default: 4
            local: false
            expose: true
            name_top: KmacNumAppIntf
          }
          default: kmac_pkg::APP_REQ_DEFAULT
          inst_name: kmac
          end_idx: -1
          top_type: one-to-N
          top_signame: kmac_app
          index: -1
        }
        {
          name: entropy
          struct: edn
          package: edn_pkg
          type: req_rsp
          act: req
          width: 1
          inst_name: kmac
          default: ""
          domain: Main
          top_signame: edn0_edn
          index: 2
        }
        {
          name: idle
          struct: mubi4
          package: prim_mubi_pkg
          type: uni
          act: req
          width: 1
          inst_name: kmac
          index: -1
        }
        {
          name: en_masking
          struct: logic
          type: uni
          act: req
          width: 1
          inst_name: kmac
          default: ""
          package: ""
          end_idx: -1
          top_type: broadcast
          top_signame: kmac_en_masking
          index: -1
        }
        {
          name: lc_escalate_en
          struct: lc_tx
          package: lc_ctrl_pkg
          type: uni
          act: rcv
          width: 1
          default: lc_ctrl_pkg::Off
          inst_name: kmac
          domain: Main
          top_signame: lc_ctrl_lc_escalate_en
          index: -1
        }
        {
          name: tl
          struct: tl
          package: tlul_pkg
          type: req_rsp
          act: rsp
          width: 1
          inst_name: kmac
          default: ""
          end_idx: -1
          top_type: one-to-one
          top_signame: kmac_tl
          index: -1
        }
      ]
      base_addrs:
      {
        null:
        {
          hart: 0x21120000
        }
      }
      generate_dif: true
      domain: Main
    }
    {
      name: otbn
      type: otbn
      clock_srcs:
      {
        clk_i: main
        clk_edn_i: main
        clk_otp_i: main
      }
      clock_group: secure
      reset_connections:
      {
        rst_ni:
        {
          name: lc_main
          domain: Main
        }
        rst_edn_ni:
        {
          name: lc_main
          domain: Main
        }
        rst_otp_ni:
        {
          name: lc_main
          domain: Main
        }
      }
      clock_connections:
      {
        clk_i: clk_main_i
        clk_edn_i: clk_main_i
        clk_otp_i: clk_main_i
      }
      param_decl: {}
      memory: {}
      param_list:
      [
        {
          name: Stub
          desc: Stub out the core of Otbn logic
          type: bit
          default: "0"
          local: "false"
          expose: "true"
          name_top: OtbnStub
        }
        {
          name: RegFile
          desc: Selection of the register file implementation. See otbn_pkg.sv.
          type: otbn_pkg::regfile_e
          default: otbn_pkg::RegFileFF
          local: "false"
          expose: "true"
          name_top: OtbnRegFile
        }
        {
          name: SecMuteUrnd
          desc:
            '''
            If enabled (1), URND is advanced only when data is needed.
            Disabled (0) by default.
            Useful for SCA measurements only.
            '''
          type: bit
          default: "0"
          local: "false"
          expose: "true"
          name_top: SecOtbnMuteUrnd
        }
        {
          name: SecFixMaiOpSeq
          desc:
            '''
            If enabled (1), masking accelerator interface will not randomize operand start indexes.
            Disabled (0) by default.
            Useful for SCA measurements only.
            '''
          type: bit
          default: "0"
          local: "false"
          expose: "true"
          name_top: SecOtbnFixMaiOpSeq
        }
        {
          name: SecSkipUrndReseedAtStart
          desc:
            '''
            If enabled (1), URND reseed is skipped at the start of an operation.
            Disabled (0) by default.
            Useful for SCA measurements only.
            '''
          type: bit
          default: "0"
          local: "false"
          expose: "true"
          name_top: SecOtbnSkipUrndReseedAtStart
        }
        {
          name: FeatStubMai
          desc:
            '''
            If enabled (1), MAI and mask accelerator are not preset in the design.
            Disabled (0) by default.
            Useful for resource-bound targets only. Can break software setups and DV.
            '''
          type: bit
          default: "0"
          local: "false"
          expose: "true"
          name_top: OtbnFeatStubMai
        }
      ]
      inter_signal_list:
      [
        {
          name: otbn_otp_key
          struct: otbn_otp_key
          package: otp_ctrl_pkg
          type: req_rsp
          act: req
          width: 1
          default: "'0"
          inst_name: otbn
          domain: Main
          top_signame: otp_ctrl_otbn_otp_key
          index: -1
        }
        {
          name: edn_rnd
          struct: edn
          package: edn_pkg
          type: req_rsp
          act: req
          width: 1
          inst_name: otbn
          default: ""
          domain: Main
          top_signame: edn1_edn
          index: 0
        }
        {
          name: edn_urnd
          struct: edn
          package: edn_pkg
          type: req_rsp
          act: req
          width: 1
          inst_name: otbn
          default: ""
          domain: Main
          top_signame: edn0_edn
          index: 5
        }
        {
          name: idle
          struct: mubi4
          package: prim_mubi_pkg
          type: uni
          act: req
          width: 1
          inst_name: otbn
          index: -1
        }
        {
          name: ram_cfg_imem
          struct: ram_1p_cfg
          package: prim_ram_1p_pkg
          type: req_rsp
          act: rsp
          width: 1
          inst_name: otbn
          index: -1
        }
        {
          name: ram_cfg_dmem
          struct: ram_1p_cfg
          package: prim_ram_1p_pkg
          type: req_rsp
          act: rsp
          width: 1
          inst_name: otbn
          index: -1
        }
        {
          name: lc_escalate_en
          struct: lc_tx
          package: lc_ctrl_pkg
          type: uni
          act: rcv
          width: 1
          default: lc_ctrl_pkg::Off
          inst_name: otbn
          domain: Main
          top_signame: lc_ctrl_lc_escalate_en
          index: -1
        }
        {
          name: lc_rma_req
          struct: lc_tx
          package: lc_ctrl_pkg
          type: uni
          act: rcv
          width: 1
          default: lc_ctrl_pkg::Off
          inst_name: otbn
          domain: Main
          top_signame: lc_ctrl_lc_nvm_rma_req
          index: -1
        }
        {
          name: lc_rma_ack
          struct: lc_tx
          package: lc_ctrl_pkg
          type: uni
          act: req
          width: 1
          default: lc_ctrl_pkg::Off
          inst_name: otbn
          end_idx: -1
          top_type: broadcast
          top_signame: otbn_lc_rma_ack
          index: -1
        }
        {
          name: keymgr_key
          struct: otbn_key_req
          package: keymgr_pkg
          type: uni
          act: rcv
          width: 1
          inst_name: otbn
          default: ""
          domain: Main
          top_signame: keymgr_dpe_otbn_key
          index: -1
        }
        {
          name: kmac_data
          struct: app
          package: kmac_pkg
          type: req_rsp
          act: req
          width: 1
          inst_name: otbn
          index: -1
        }
        {
          name: tl
          struct: tl
          package: tlul_pkg
          type: req_rsp
          act: rsp
          width: 1
          inst_name: otbn
          default: ""
          end_idx: -1
          top_type: one-to-one
          top_signame: otbn_tl
          index: -1
        }
      ]
      base_addrs:
      {
        null:
        {
          hart: 0x21130000
        }
      }
      generate_dif: true
      domain: Main
    }
    {
      name: keymgr_dpe
      type: keymgr_dpe
      param_decl:
      {
        NumRomDigestInputs: 1
      }
      clock_srcs:
      {
        clk_i: main
        clk_edn_i: main
      }
      clock_group: secure
      reset_connections:
      {
        rst_ni:
        {
          name: lc_main
          domain: Main
        }
        rst_edn_ni:
        {
          name: lc_main
          domain: Main
        }
      }
      clock_connections:
      {
        clk_i: clk_main_i
        clk_edn_i: clk_main_i
      }
      memory: {}
      param_list:
      [
        {
          name: KmacEnMasking
          desc: Flag indicating with kmac masking is enabled
          type: bit
          default: "1"
          local: "false"
          expose: "true"
          name_top: KeymgrDpeKmacEnMasking
        }
        {
          name: NumRomDigestInputs
          desc: Number of digest inputs from ROM_CTRL
          type: int
          default: 1
          local: "false"
          expose: "true"
          name_top: KeymgrDpeNumRomDigestInputs
        }
      ]
      inter_signal_list:
      [
        {
          name: edn
          struct: edn
          package: edn_pkg
          type: req_rsp
          act: req
          width: 1
          inst_name: keymgr_dpe
          default: ""
          domain: Main
          top_signame: edn0_edn
          index: 0
        }
        {
          name: aes_key
          struct: hw_key_req
          package: keymgr_pkg
          type: uni
          act: req
          width: 1
          inst_name: keymgr_dpe
          default: ""
          end_idx: -1
          top_type: broadcast
          top_signame: keymgr_dpe_aes_key
          index: -1
        }
        {
          name: kmac_key
          struct: hw_key_req
          package: keymgr_pkg
          type: uni
          act: req
          width: 1
          inst_name: keymgr_dpe
          default: ""
          end_idx: -1
          top_type: broadcast
          top_signame: keymgr_dpe_kmac_key
          index: -1
        }
        {
          name: otbn_key
          struct: otbn_key_req
          package: keymgr_pkg
          type: uni
          act: req
          width: 1
          inst_name: keymgr_dpe
          default: ""
          end_idx: -1
          top_type: broadcast
          top_signame: keymgr_dpe_otbn_key
          index: -1
        }
        {
          name: kmac_data
          struct: app
          package: kmac_pkg
          type: req_rsp
          act: req
          width: 1
          inst_name: keymgr_dpe
          default: ""
          domain: Main
          top_signame: kmac_app
          index: 0
        }
        {
          name: creator_root_key
          struct: keymgr_dpe_creator_root_key
          package: keymgr_dpe_pkg
          type: uni
          act: rcv
          width: 1
          inst_name: keymgr_dpe
          default: ""
          domain: Main
          top_signame: otp_ctrl_keymgr_creator_root_key
          index: -1
        }
        {
          name: creator_seed
          struct: keymgr_dpe_creator_seed
          package: keymgr_dpe_pkg
          type: uni
          act: rcv
          width: 1
          inst_name: keymgr_dpe
          default: ""
          domain: Main
          top_signame: otp_ctrl_keymgr_creator_seed
          index: -1
        }
        {
          name: owner_seed
          struct: keymgr_dpe_owner_seed
          package: keymgr_dpe_pkg
          type: uni
          act: rcv
          width: 1
          inst_name: keymgr_dpe
          default: ""
          domain: Main
          top_signame: otp_ctrl_keymgr_owner_seed
          index: -1
        }
        {
          name: device_id
          struct: keymgr_dpe_device_id
          package: keymgr_dpe_pkg
          type: uni
          act: rcv
          width: 1
          inst_name: keymgr_dpe
          default: ""
          top_signame: keymgr_dpe_device_id
          index: -1
        }
        {
          name: lc_keymgr_en
          struct: lc_tx
          package: lc_ctrl_pkg
          type: uni
          act: rcv
          width: 1
          default: lc_ctrl_pkg::On
          inst_name: keymgr_dpe
          domain: Main
          top_signame: lc_ctrl_lc_keymgr_en
          index: -1
        }
        {
          name: lc_keymgr_div
          struct: lc_keymgr_div
          package: lc_ctrl_pkg
          type: uni
          act: rcv
          width: 1
          inst_name: keymgr_dpe
          default: ""
          domain: Main
          top_signame: lc_ctrl_lc_keymgr_div
          index: -1
        }
        {
          name: rom_digest
          struct: keymgr_data
          package: rom_ctrl_pkg
          type: uni
          act: rcv
          width:
          {
            name: NumRomDigestInputs
            desc: Number of digest inputs from ROM_CTRL
            param_type: int
            unpacked_dimensions: null
            default: 2
            local: false
            expose: true
            name_top: KeymgrDpeNumRomDigestInputs
          }
          default: rom_ctrl_pkg::KEYMGR_DATA_DEFAULT
          inst_name: keymgr_dpe
          end_idx: -1
          top_type: broadcast
          top_signame: keymgr_dpe_rom_digest
          index: -1
        }
        {
          name: kmac_en_masking
          struct: logic
          type: uni
          act: rcv
          width: 1
          inst_name: keymgr_dpe
          default: ""
          package: ""
          domain: Main
          top_signame: kmac_en_masking
          index: -1
        }
        {
          name: tl
          struct: tl
          package: tlul_pkg
          type: req_rsp
          act: rsp
          width: 1
          inst_name: keymgr_dpe
          default: ""
          end_idx: -1
          top_type: one-to-one
          top_signame: keymgr_dpe_tl
          index: -1
        }
      ]
      base_addrs:
      {
        null:
        {
          hart: 0x21140000
        }
      }
      generate_dif: true
      domain: Main
    }
    {
      name: csrng
      type: csrng
      clock_srcs:
      {
        clk_i: main
      }
      clock_group: secure
      reset_connections:
      {
        rst_ni:
        {
          name: lc_main
          domain: Main
        }
      }
      clock_connections:
      {
        clk_i: clk_main_i
      }
      param_decl: {}
      memory: {}
      param_list:
      [
        {
          name: SBoxImpl
          desc: Selection of the S-Box implementation. See aes_pkg.sv.
          type: aes_pkg::sbox_impl_e
          default: aes_pkg::SBoxImplCanright
          local: "false"
          expose: "true"
          name_top: CsrngSBoxImpl
        }
      ]
      inter_signal_list:
      [
        {
          name: csrng_cmd
          struct: csrng
          package: csrng_pkg
          type: req_rsp
          act: rsp
          width: 2
          inst_name: csrng
          default: ""
          end_idx: -1
          top_type: one-to-N
          top_signame: csrng_csrng_cmd
          index: -1
        }
        {
          name: entropy_src_hw_if
          struct: entropy_src_hw_if
          package: entropy_src_pkg
          type: req_rsp
          act: req
          width: 1
          inst_name: csrng
          default: ""
          end_idx: -1
          top_type: one-to-one
          top_signame: csrng_entropy_src_hw_if
          index: -1
        }
        {
          name: otp_en_csrng_sw_app_read
          struct: mubi8
          package: prim_mubi_pkg
          type: uni
          act: rcv
          width: 1
          default: prim_mubi_pkg::MuBi8True
          inst_name: csrng
          top_signame: csrng_otp_en_csrng_sw_app_read
          index: -1
        }
        {
          name: lc_hw_debug_en
          struct: lc_tx
          package: lc_ctrl_pkg
          type: uni
          act: rcv
          width: 1
          default: lc_ctrl_pkg::Off
          inst_name: csrng
          domain: Main
          top_signame: lc_ctrl_lc_hw_debug_en
          index: -1
        }
        {
          name: tl
          struct: tl
          package: tlul_pkg
          type: req_rsp
          act: rsp
          width: 1
          inst_name: csrng
          default: ""
          end_idx: -1
          top_type: one-to-one
          top_signame: csrng_tl
          index: -1
        }
      ]
      base_addrs:
      {
        null:
        {
          hart: 0x21150000
        }
      }
      generate_dif: true
      domain: Main
    }
    {
      name: entropy_src
      type: entropy_src
      clock_srcs:
      {
        clk_i: main
      }
      clock_group: secure
      reset_connections:
      {
        rst_ni:
        {
          name: lc_main
          domain: Main
        }
      }
      param_decl:
      {
        RngBusWidth: "4"
        RngBusBitSelWidth: "2"
      }
      clock_connections:
      {
        clk_i: clk_main_i
      }
      memory: {}
      param_list:
      [
        {
          name: RngBusWidth
          desc:
            '''
            Defines the bit-width of the noise source data.
            Must be between 4 and 256 (inclusive) and divisible by 4.
            The divisibility by 4 is a prerequisite for the bucket health test.
            '''
          type: int
          default: "4"
          local: "false"
          expose: "true"
          name_top: EntropySrcRngBusWidth
        }
        {
          name: RngBusBitSelWidth
          desc: Explicit parameter defining the width of the RNG bit selection vector (log2(RngBusWidth))
          type: int
          default: "2"
          local: "false"
          expose: "true"
          name_top: EntropySrcRngBusBitSelWidth
        }
        {
          name: HealthTestWindowWidth
          desc: Explicit parameter defining the width of the health test window (16 + log2(RngBusWidth))
          type: int
          default: 18
          local: "false"
          expose: "true"
          name_top: EntropySrcHealthTestWindowWidth
        }
        {
          name: EsFifoDepth
          desc: Number of 384-bit entries in the esfinal FIFO
          type: int
          default: "3"
          local: "true"
          expose: "true"
          name_top: EntropySrcEsFifoDepth
        }
        {
          name: DistrFifoDepth
          desc: Number of 32-bit entries in the distr FIFO
          type: int unsigned
          default: "3"
          local: "true"
          expose: "true"
          name_top: EntropySrcDistrFifoDepth
        }
        {
          name: Stub
          desc: Stub out the core of entropy_src logic
          type: bit
          default: "0"
          local: "false"
          expose: "true"
          name_top: EntropySrcStub
        }
      ]
      inter_signal_list:
      [
        {
          name: entropy_src_hw_if
          struct: entropy_src_hw_if
          package: entropy_src_pkg
          type: req_rsp
          act: rsp
          width: 1
          inst_name: entropy_src
          default: ""
          domain: Main
          top_signame: csrng_entropy_src_hw_if
          index: -1
        }
        {
          name: entropy_src_rng_enable
          desc:
            '''
            Signal through which entropy_src enables the noise source.
            entropy_src will keep this signal high as long as it expects the noise source to operate.
            This is *not* a flow control signal through which entropy_src would exert backpressure on the noise source; rather this signal stays high while entropy_src is enabled.
            '''
          struct: logic
          type: uni
          act: req
          width: 1
          inst_name: entropy_src
          default: ""
          package: ""
          external: true
          conn_type: false
          index: -1
          top_signame: es_rng_enable
        }
        {
          name: entropy_src_rng_valid
          desc:
            '''
            Acknowledgement signal from the noise source.
            When '1', it indicates that the `entropy_src_rng_bit` data is valid and ready to be consumed.
            '''
          struct: logic
          type: uni
          act: rcv
          width: 1
          inst_name: entropy_src
          default: ""
          package: ""
          external: true
          conn_type: false
          index: -1
          top_signame: es_rng_valid
        }
        {
          name: entropy_src_rng_bits
          desc:
            '''
            Output data bus carrying the raw entropy bits from the noise source.
            These bits are valid when `entropy_src_rng_valid` is asserted.
            The width is determined by `RngBusWidth` parametrization.
            '''
          struct: logic
          type: uni
          act: rcv
          width:
          {
            name: RngBusWidth
            desc:
              '''
              Defines the bit-width of the noise source data.
              Must be between 4 and 256 (inclusive) and divisible by 4.
              The divisibility by 4 is a prerequisite for the bucket health test.
              '''
            param_type: int
            unpacked_dimensions: null
            default: 4
            local: false
            expose: true
            name_top: EntropySrcRngBusWidth
          }
          inst_name: entropy_src
          default: ""
          package: ""
          external: true
          conn_type: false
          index: -1
          top_signame: es_rng_bit
        }
        {
          name: entropy_src_xht_valid
          desc:
            '''
            Valid signal for the external health test interface.
            When asserted, it indicates that `entropy_src_xht_bits`, `entropy_src_xht_bit_sel`, and `entropy_src_xht_meta` are valid for consumption by the external health test.
            '''
          struct: logic
          type: uni
          act: req
          width: 1
          inst_name: entropy_src
          index: -1
        }
        {
          name: entropy_src_xht_bits
          desc:
            '''
            Carries the raw entropy data from the entropy source to be consumed by the external health test module.
            The data on this bus is valid when `entropy_src_xht_valid` is asserted.
            The width is determined by `RngBusWidth` parametrization.
            '''
          struct: logic
          type: uni
          act: req
          width:
          {
            name: RngBusWidth
            desc:
              '''
              Defines the bit-width of the noise source data.
              Must be between 4 and 256 (inclusive) and divisible by 4.
              The divisibility by 4 is a prerequisite for the bucket health test.
              '''
            param_type: int
            unpacked_dimensions: null
            default: 4
            local: false
            expose: true
            name_top: EntropySrcRngBusWidth
          }
          inst_name: entropy_src
          index: -1
        }
        {
          name: entropy_src_xht_bit_sel
          desc:
            '''
            Provides bit selection information for the raw entropy data.
            It specifies which specific bit or subset of bits from `entropy_src_xht_bit` should be used.
            The width is determined by `RngBusBitSelWidth` parametrization.
            '''
          struct: logic
          type: uni
          act: req
          width:
          {
            name: RngBusBitSelWidth
            desc: Explicit parameter defining the width of the RNG bit selection vector (log2(RngBusWidth))
            param_type: int
            unpacked_dimensions: null
            default: 2
            local: false
            expose: true
            name_top: EntropySrcRngBusBitSelWidth
          }
          inst_name: entropy_src
          index: -1
        }
        {
          name: entropy_src_xht_health_test_window
          desc: Provides the window size of the health in bits.
          struct: logic
          type: uni
          act: req
          width:
          {
            name: HealthTestWindowWidth
            desc: Explicit parameter defining the width of the health test window (16 + log2(RngBusWidth))
            param_type: int
            unpacked_dimensions: null
            default: 18
            local: false
            expose: true
            name_top: EntropySrcHealthTestWindowWidth
          }
          inst_name: entropy_src
          index: -1
        }
        {
          name: entropy_src_xht_meta
          struct: entropy_src_xht_meta
          package: entropy_src_pkg
          type: req_rsp
          act: req
          width: 1
          inst_name: entropy_src
          index: -1
        }
        {
          name: otp_en_entropy_src_fw_read
          struct: mubi8
          package: prim_mubi_pkg
          type: uni
          act: rcv
          width: 1
          default: prim_mubi_pkg::MuBi8True
          inst_name: entropy_src
          index: -1
        }
        {
          name: otp_en_entropy_src_fw_over
          struct: mubi8
          package: prim_mubi_pkg
          type: uni
          act: rcv
          width: 1
          default: prim_mubi_pkg::MuBi8True
          inst_name: entropy_src
          index: -1
        }
        {
          name: rng_fips
          struct: logic
          type: uni
          act: req
          width: 1
          inst_name: entropy_src
          default: ""
          package: ""
          external: true
          conn_type: false
          index: -1
          top_signame: es_rng_fips
        }
        {
          name: tl
          struct: tl
          package: tlul_pkg
          type: req_rsp
          act: rsp
          width: 1
          inst_name: entropy_src
          default: ""
          end_idx: -1
          top_type: one-to-one
          top_signame: entropy_src_tl
          index: -1
        }
      ]
      base_addrs:
      {
        null:
        {
          hart: 0x21160000
        }
      }
      generate_dif: true
      domain: Main
    }
    {
      name: edn0
      type: edn
      clock_srcs:
      {
        clk_i: main
      }
      clock_group: secure
      reset_connections:
      {
        rst_ni:
        {
          name: lc_main
          domain: Main
        }
      }
      param_decl:
      {
        NumEndPoints: "8"
      }
      clock_connections:
      {
        clk_i: clk_main_i
      }
      memory: {}
      param_list:
      [
        {
          name: NumEndPoints
          desc: Number of endpoints
          type: int unsigned
          default: "8"
          local: "true"
          expose: "true"
          name_top: Edn0NumEndPoints
        }
      ]
      inter_signal_list:
      [
        {
          name: csrng_cmd
          desc: EDN supports a single CSRNG application interface.
          struct: csrng
          package: csrng_pkg
          type: req_rsp
          act: req
          width: 1
          inst_name: edn0
          default: ""
          domain: Main
          top_signame: csrng_csrng_cmd
          index: 0
        }
        {
          name: edn
          desc: Every endpoint has its own peripheral port.
          struct: edn
          package: edn_pkg
          type: req_rsp
          act: rsp
          width:
          {
            name: NumEndPoints
            desc: Number of endpoints
            param_type: int unsigned
            unpacked_dimensions: null
            default: 8
            local: true
            expose: true
            name_top: Edn0NumEndPoints
          }
          default: "'0"
          inst_name: edn0
          end_idx: 7
          top_type: partial-one-to-N
          top_signame: edn0_edn
          index: 3
          external: true
          conn_type: true
        }
        {
          name: tl
          struct: tl
          package: tlul_pkg
          type: req_rsp
          act: rsp
          width: 1
          inst_name: edn0
          default: ""
          end_idx: -1
          top_type: one-to-one
          top_signame: edn0_tl
          index: -1
        }
      ]
      base_addrs:
      {
        null:
        {
          hart: 0x21170000
        }
      }
      generate_dif: true
      domain: Main
    }
    {
      name: edn1
      type: edn
      clock_srcs:
      {
        clk_i: main
      }
      clock_group: secure
      reset_connections:
      {
        rst_ni:
        {
          name: lc_main
          domain: Main
        }
      }
      param_decl:
      {
        NumEndPoints: "1"
      }
      clock_connections:
      {
        clk_i: clk_main_i
      }
      memory: {}
      param_list:
      [
        {
          name: NumEndPoints
          desc: Number of endpoints
          type: int unsigned
          default: "1"
          local: "true"
          expose: "true"
          name_top: Edn1NumEndPoints
        }
      ]
      inter_signal_list:
      [
        {
          name: csrng_cmd
          desc: EDN supports a single CSRNG application interface.
          struct: csrng
          package: csrng_pkg
          type: req_rsp
          act: req
          width: 1
          inst_name: edn1
          default: ""
          domain: Main
          top_signame: csrng_csrng_cmd
          index: 1
        }
        {
          name: edn
          desc: Every endpoint has its own peripheral port.
          struct: edn
          package: edn_pkg
          type: req_rsp
          act: rsp
          width:
          {
            name: NumEndPoints
            desc: Number of endpoints
            param_type: int unsigned
            unpacked_dimensions: null
            default: 8
            local: true
            expose: true
            name_top: Edn1NumEndPoints
          }
          default: "'0"
          inst_name: edn1
          end_idx: -1
          top_type: one-to-one
          top_signame: edn1_edn
          index: -1
        }
        {
          name: tl
          struct: tl
          package: tlul_pkg
          type: req_rsp
          act: rsp
          width: 1
          inst_name: edn1
          default: ""
          end_idx: -1
          top_type: one-to-one
          top_signame: edn1_tl
          index: -1
        }
      ]
      base_addrs:
      {
        null:
        {
          hart: 0x21180000
        }
      }
      generate_dif: true
      domain: Main
    }
    {
      name: sram_ctrl_main
      type: sram_ctrl
      clock_srcs:
      {
        clk_i: main
        clk_otp_i: main
      }
      clock_group: secure
      reset_connections:
      {
        rst_ni:
        {
          name: lc_main
          domain: Main
        }
        rst_otp_ni:
        {
          name: lc_main
          domain: Main
        }
      }
      param_decl:
      {
        InstrExec: "1"
        NumPrinceRoundsHalf: "2"
        InstSize: "196608"
      }
      base_addrs:
      {
        regs:
        {
          hart: 0x211c0000
        }
        ram:
        {
          hart: 0x10000000
        }
      }
      memory:
      {
        ram:
        {
          label: ram_main
          swaccess: rw
          data_intg_passthru: "true"
          exec: True
          byte_write: True
          size: 0x30000
        }
      }
      clock_connections:
      {
        clk_i: clk_main_i
        clk_otp_i: clk_main_i
      }
      param_list:
      [
        {
          name: MemSizeRam
          desc: Memory size of the RAM (in bytes).
          type: int
          name_top: MemSizeSramCtrlMainRam
          default: 196608
        }
        {
          name: InstSize
          desc: Memory size of a single RAM tile (in bytes).
          type: int
          default: "196608"
          local: "false"
          expose: "true"
          name_top: SramCtrlMainInstSize
        }
        {
          name: NumRamInst
          desc: Number of internal RAM instances. Must be the same as ceil(MemSizeRam / InstSize) .
          type: int
          default: 1
          local: "false"
          expose: "true"
          name_top: SramCtrlMainNumRamInst
        }
        {
          name: InstrExec
          desc: Support execution from SRAM
          type: bit
          default: "1"
          local: "false"
          expose: "true"
          name_top: SramCtrlMainInstrExec
        }
        {
          name: NumPrinceRoundsHalf
          desc: Number of PRINCE half rounds for the SRAM scrambling feature
          type: int
          default: "2"
          local: "false"
          expose: "true"
          name_top: SramCtrlMainNumPrinceRoundsHalf
        }
        {
          name: Outstanding
          desc: Number of outstanding TLUL transactions
          type: int
          default: "2"
          local: "true"
          expose: "true"
          name_top: SramCtrlMainOutstanding
        }
        {
          name: EccCorrection
          desc: Enable single-bit error correction and error logging
          type: bit
          default: "0"
          local: "false"
          expose: "true"
          name_top: SramCtrlMainEccCorrection
        }
      ]
      inter_signal_list:
      [
        {
          name: sram_otp_key
          struct: sram_otp_key
          package: otp_ctrl_pkg
          type: req_rsp
          act: req
          width: 1
          inst_name: sram_ctrl_main
          default: ""
          domain: Main
          top_signame: otp_ctrl_sram_otp_key
          index: 0
        }
        {
          name: ram_cfg
          struct: ram_1p_cfg
          package: prim_ram_1p_pkg
          type: req_rsp
          act: rsp
          width:
          {
            name: NumRamInst
            desc: Number of internal RAM instances. Must be the same as ceil(MemSizeRam / InstSize) .
            param_type: int
            unpacked_dimensions: null
            default: 1
            local: false
            expose: true
            name_top: SramCtrlMainNumRamInst
          }
          inst_name: sram_ctrl_main
          index: -1
        }
        {
          name: lc_escalate_en
          struct: lc_tx
          package: lc_ctrl_pkg
          type: uni
          act: rcv
          width: 1
          default: lc_ctrl_pkg::Off
          inst_name: sram_ctrl_main
          domain: Main
          top_signame: lc_ctrl_lc_escalate_en
          index: -1
        }
        {
          name: lc_hw_debug_en
          struct: lc_tx
          package: lc_ctrl_pkg
          type: uni
          act: rcv
          width: 1
          default: lc_ctrl_pkg::Off
          inst_name: sram_ctrl_main
          domain: Main
          top_signame: lc_ctrl_lc_hw_debug_en
          index: -1
        }
        {
          name: otp_en_sram_ifetch
          struct: mubi8
          package: prim_mubi_pkg
          type: uni
          act: rcv
          width: 1
          default: prim_mubi_pkg::MuBi8False
          inst_name: sram_ctrl_main
          top_signame: sram_ctrl_main_otp_en_sram_ifetch
          index: -1
        }
        {
          name: racl_policies
          desc:
            '''
            Incoming RACL policy vector from a racl_ctrl instance.
            The policy selection vector (parameter) selects the policy for each register.
            '''
          struct: racl_policy_vec
          package: top_racl_pkg
          type: uni
          act: rcv
          width: 1
          inst_name: sram_ctrl_main
          index: -1
        }
        {
          name: racl_error
          desc: RACL error log information of this module.
          struct: racl_error_log
          package: top_racl_pkg
          type: uni
          act: req
          width: 1
          inst_name: sram_ctrl_main
          index: -1
        }
        {
          name: sram_rerror
          desc: SRAM read error indicating correctable and uncorrectable ECC errors.
          struct: sram_error_t
          package: sram_ctrl_pkg
          type: uni
          act: req
          width: 1
          inst_name: sram_ctrl_main
          index: -1
        }
        {
          name: regs_tl
          struct: tl
          package: tlul_pkg
          type: req_rsp
          act: rsp
          width: 1
          inst_name: sram_ctrl_main
          default: ""
          end_idx: -1
          top_type: one-to-one
          top_signame: sram_ctrl_main_regs_tl
          index: -1
        }
        {
          name: ram_tl
          struct: tl
          package: tlul_pkg
          type: req_rsp
          act: rsp
          width: 1
          inst_name: sram_ctrl_main
          default: ""
          end_idx: -1
          top_type: one-to-one
          top_signame: sram_ctrl_main_ram_tl
          index: -1
        }
      ]
      generate_dif: true
      domain: Main
    }
    {
      name: rom_ctrl
      type: rom_ctrl
      clock_srcs:
      {
        clk_i: main
      }
      clock_group: secure
      reset_connections:
      {
        rst_ni:
        {
          name: lc_main
          domain: Main
        }
      }
      base_addrs:
      {
        rom:
        {
          hart: 0x00020000
        }
        regs:
        {
          hart: 0x211e0000
        }
      }
      memory:
      {
        rom:
        {
          label: rom
          swaccess: ro
          data_intg_passthru: True
          exec: True
          byte_write: False
          size: 0x20000
        }
      }
      param_decl:
      {
        SecDisableScrambling: 1'b0
        FlopToKmac: 1'b1
      }
      clock_connections:
      {
        clk_i: clk_main_i
      }
      param_list:
      [
        {
          name: BootRomInitFile
          desc: Contents of ROM
          type: ""
          default: '''""'''
          local: "false"
          expose: "true"
          name_top: RomCtrlBootRomInitFile
        }
        {
          name: FlopToKmac
          desc:
            '''
            Add a flop stage between the output of the ROM and the data that gets
            sent to KMAC. This may break long paths in a target chip, at the cost of
            adding chip area.
            '''
          type: bit
          default: 1'b1
          local: "true"
          expose: "true"
          name_top: RomCtrlFlopToKmac
        }
        {
          name: SecDisableScrambling
          desc:
            '''
            Disable scrambling and checking in rom_ctrl, turning the block into a
            simple ROM wrapper. This isn't intended for real chips, but is useful
            for small FPGA targets where there's not space for the PRINCE
            primitives.
            '''
          type: bit
          default: 1'b0
          local: "false"
          expose: "true"
          name_top: SecRomCtrlDisableScrambling
        }
        {
          name: MemSizeRom
          desc: Memory size of the ROM (in bytes).
          type: int
          name_top: MemSizeRomCtrlRom
          default: 131072
        }
      ]
      inter_signal_list:
      [
        {
          name: rom_cfg
          struct: rom_cfg
          package: prim_rom_pkg
          type: req_rsp
          act: rsp
          width: 1
          inst_name: rom_ctrl
          index: -1
        }
        {
          name: pwrmgr_data
          struct: pwrmgr_data
          package: rom_ctrl_pkg
          type: uni
          act: req
          width: 1
          inst_name: rom_ctrl
          default: ""
          domain: Main
          top_signame: pwrmgr_rom_ctrl
          index: -1
          external: true
          conn_type: false
        }
        {
          name: keymgr_data
          struct: keymgr_data
          package: rom_ctrl_pkg
          type: uni
          act: req
          width: 1
          inst_name: rom_ctrl
          default: ""
          domain: Main
          top_signame: keymgr_dpe_rom_digest
          index: -1
        }
        {
          name: kmac_data
          struct: app
          package: kmac_pkg
          type: req_rsp
          act: req
          width: 1
          inst_name: rom_ctrl
          default: ""
          domain: Main
          top_signame: kmac_app
          index: 2
        }
        {
          name: regs_tl
          struct: tl
          package: tlul_pkg
          type: req_rsp
          act: rsp
          width: 1
          inst_name: rom_ctrl
          default: ""
          end_idx: -1
          top_type: one-to-one
          top_signame: rom_ctrl_regs_tl
          index: -1
        }
        {
          name: rom_tl
          struct: tl
          package: tlul_pkg
          type: req_rsp
          act: rsp
          width: 1
          inst_name: rom_ctrl
          default: ""
          end_idx: -1
          top_type: one-to-one
          top_signame: rom_ctrl_rom_tl
          index: -1
        }
      ]
      generate_dif: true
      domain: Main
    }
    {
      name: dma
      type: dma
      clock_srcs:
      {
        clk_i: main
      }
      clock_group: secure
      reset_connections:
      {
        rst_ni:
        {
          name: lc_main
          domain: Main
        }
      }
      clock_connections:
      {
        clk_i: clk_main_i
      }
      param_decl: {}
      memory: {}
      param_list:
      [
        {
          name: EnableDataIntgGen
          desc: Compute integrity bits for A channel data on all TL-UL host ports
          type: bit
          default: 1'b1
          local: "false"
          expose: "true"
          name_top: DmaEnableDataIntgGen
        }
        {
          name: EnableRspDataIntgCheck
          desc: Enable integrity checks on the response TL-UL D channel
          type: bit
          default: 1'b1
          local: "false"
          expose: "true"
          name_top: DmaEnableRspDataIntgCheck
        }
        {
          name: TlUserRsvd
          desc: Value of `rsvd` field in A channel of all TL-UL host ports
          type: logic [tlul_pkg::RsvdWidth-1:0]
          default: "'0"
          local: "false"
          expose: "true"
          name_top: DmaTlUserRsvd
        }
        {
          name: SysRaclRole
          desc: RACL propagated on the Sys interface via `racl_vec`
          type: top_racl_pkg::racl_role_t
          default: "'0"
          local: "false"
          expose: "true"
          name_top: DmaSysRaclRole
        }
        {
          name: OtAgentId
          desc: OT Agent ID
          type: int unsigned
          default: "0"
          local: "false"
          expose: "true"
          name_top: DmaOtAgentId
        }
      ]
      inter_signal_list:
      [
        {
          name: lsio_trigger
          struct: lsio_trigger
          package: dma_pkg
          type: uni
          act: rcv
          width: 1
          inst_name: dma
          default: ""
          end_idx: -1
          top_type: broadcast
          index: -1
        }
        {
          name: sys
          desc: SoC System Bus (requests and responses), synchronous
          struct: sys
          package: dma_pkg
          type: req_rsp
          act: req
          width: 1
          default: dma_pkg::SYS_RSP_DEFAULT
          inst_name: dma
          end_idx: -1
          top_type: broadcast
          index: -1
        }
        {
          name: ctn_tl_h2d
          desc: TL-UL host port for egress into CTN (request part), synchronous
          struct: tl_h2d
          package: tlul_pkg
          type: uni
          act: req
          width: 1
          inst_name: dma
          index: -1
        }
        {
          name: ctn_tl_d2h
          desc: TL-UL host port for egress into CTN (response part), synchronous
          struct: tl_d2h
          package: tlul_pkg
          type: uni
          act: rcv
          width: 1
          inst_name: dma
          index: -1
        }
        {
          name: racl_policies
          desc:
            '''
            Incoming RACL policy vector from a racl_ctrl instance.
            The policy selection vector (parameter) selects the policy for each register.
            '''
          struct: racl_policy_vec
          package: top_racl_pkg
          type: uni
          act: rcv
          width: 1
          inst_name: dma
          index: -1
        }
        {
          name: racl_error
          desc: RACL error log information of this module.
          struct: racl_error_log
          package: top_racl_pkg
          type: uni
          act: req
          width: 1
          inst_name: dma
          index: -1
        }
        {
          name: host_tl_h
          struct: tl
          package: tlul_pkg
          type: req_rsp
          act: req
          width: 1
          inst_name: dma
          default: ""
          domain: Main
          top_signame: main_tl_dma__host
          index: -1
        }
        {
          name: tl_d
          struct: tl
          package: tlul_pkg
          type: req_rsp
          act: rsp
          width: 1
          inst_name: dma
          default: ""
          end_idx: -1
          top_type: one-to-one
          top_signame: dma_tl_d
          index: -1
        }
      ]
      base_addrs:
      {
        null:
        {
          hart: 0x22010000
        }
      }
      generate_dif: true
      domain: Main
    }
    {
      name: ahb_bridge
      type: ahb_bridge
      attr: reggen_top
      clock_srcs:
      {
        clk_i: main
      }
      clock_group: secure
      reset_connections:
      {
        rst_ni:
        {
          name: lc_main
          domain: Main
        }
      }
      base_addrs:
      {
        ctn:
        {
          hart: 0x80000000
        }
      }
      memory:
      {
        ctn:
        {
          label: ctn
          swaccess: rw
          data_intg_passthru: "true"
          exec: True
          byte_write: True
          size: 0x10000000
        }
      }
      clock_connections:
      {
        clk_i: clk_main_i
      }
      param_decl: {}
      param_list: []
      inter_signal_list:
      [
        {
          name: ahb_sub_m2s
          desc: AHB subordinate request in (external SoC AHB manager)
          struct: ahb_m2s
          package: ahb_pkg
          type: uni
          act: rcv
          width: 1
          inst_name: ahb_bridge
          default: ""
          external: true
          conn_type: false
          index: -1
          top_signame: soc_mbx_ahb_req
        }
        {
          name: ahb_sub_s2m
          desc: AHB subordinate response out
          struct: ahb_s2m
          package: ahb_pkg
          type: uni
          act: req
          width: 1
          inst_name: ahb_bridge
          default: ""
          external: true
          conn_type: false
          index: -1
          top_signame: soc_mbx_ahb_rsp
        }
        {
          name: ahb_mgr_m2s
          desc: AHB manager request out (to external SoC AHB subordinate)
          struct: ahb_m2s
          package: ahb_pkg
          type: uni
          act: req
          width: 1
          inst_name: ahb_bridge
          default: ""
          external: true
          conn_type: false
          index: -1
          top_signame: soc_mgr_ahb_req
        }
        {
          name: ahb_mgr_s2m
          desc: AHB manager response in
          struct: ahb_s2m
          package: ahb_pkg
          type: uni
          act: rcv
          width: 1
          inst_name: ahb_bridge
          default: ""
          external: true
          conn_type: false
          index: -1
          top_signame: soc_mgr_ahb_rsp
        }
        {
          name: socmbx_tl_h
          struct: tl
          package: tlul_pkg
          type: req_rsp
          act: req
          width: 1
          inst_name: ahb_bridge
          default: ""
          domain: Main
          top_signame: socmbx_tl_ahb_bridge__socmbx
          index: -1
        }
        {
          name: ctn_tl_d
          struct: tl
          package: tlul_pkg
          type: req_rsp
          act: rsp
          width: 1
          inst_name: ahb_bridge
          default: ""
          end_idx: -1
          top_type: one-to-one
          top_signame: ahb_bridge_ctn_tl_d
          index: -1
        }
      ]
      generate_dif: true
      domain: Main
    }
    {
      name: mbx0
      type: mbx
      clock_srcs:
      {
        clk_i: main
      }
      clock_group: secure
      reset_connections:
      {
        rst_ni:
        {
          name: lc_main
          domain: Main
        }
      }
      base_addrs:
      {
        core:
        {
          hart: 0x22000000
        }
        soc:
        {
          soc_mbx: 0x00000000
        }
      }
      clock_connections:
      {
        clk_i: clk_main_i
      }
      param_decl: {}
      memory: {}
      param_list: []
      inter_signal_list:
      [
        {
          name: doe_intr_support
          struct: logic
          type: uni
          act: req
          width: 1
          default: 1'b0
          inst_name: mbx0
          package: ""
          external: true
          conn_type: false
          index: -1
          top_signame: mbx0_doe_intr_support
        }
        {
          name: doe_intr_en
          struct: logic
          type: uni
          act: req
          width: 1
          default: 1'b0
          inst_name: mbx0
          package: ""
          external: true
          conn_type: false
          index: -1
          top_signame: mbx0_doe_intr_en
        }
        {
          name: doe_intr
          struct: logic
          type: uni
          act: req
          width: 1
          default: 1'b0
          inst_name: mbx0
          package: ""
          external: true
          conn_type: false
          index: -1
          top_signame: mbx0_doe_intr
        }
        {
          name: doe_async_msg_support
          struct: logic
          type: uni
          act: req
          width: 1
          default: 1'b0
          inst_name: mbx0
          package: ""
          external: true
          conn_type: false
          index: -1
          top_signame: mbx0_doe_async_msg_support
        }
        {
          name: racl_policies
          desc:
            '''
            Incoming RACL policy vector from a racl_ctrl instance.
            The policy selection vector (parameter) selects the policy for each register.
            '''
          struct: racl_policy_vec
          package: top_racl_pkg
          type: uni
          act: rcv
          width: 1
          inst_name: mbx0
          index: -1
        }
        {
          name: racl_error
          desc: RACL error log information of this module.
          struct: racl_error_log
          package: top_racl_pkg
          type: uni
          act: req
          width: 1
          inst_name: mbx0
          index: -1
        }
        {
          name: sram_tl_h
          struct: tl
          package: tlul_pkg
          type: req_rsp
          act: req
          width: 1
          inst_name: mbx0
          default: ""
          domain: Main
          top_signame: main_tl_mbx0__sram
          index: -1
        }
        {
          name: core_tl_d
          struct: tl
          package: tlul_pkg
          type: req_rsp
          act: rsp
          width: 1
          inst_name: mbx0
          default: ""
          end_idx: -1
          top_type: one-to-one
          top_signame: mbx0_core_tl_d
          index: -1
        }
        {
          name: soc_tl_d
          struct: tl
          package: tlul_pkg
          type: req_rsp
          act: rsp
          width: 1
          inst_name: mbx0
          default: ""
          end_idx: -1
          top_type: one-to-one
          top_signame: mbx0_soc_tl_d
          index: -1
        }
      ]
      generate_dif: true
      domain: Main
    }
    {
      name: mbx1
      type: mbx
      clock_srcs:
      {
        clk_i: main
      }
      clock_group: secure
      reset_connections:
      {
        rst_ni:
        {
          name: lc_main
          domain: Main
        }
      }
      base_addrs:
      {
        core:
        {
          hart: 0x22000100
        }
        soc:
        {
          soc_mbx: 0x00000100
        }
      }
      clock_connections:
      {
        clk_i: clk_main_i
      }
      param_decl: {}
      memory: {}
      param_list: []
      inter_signal_list:
      [
        {
          name: doe_intr_support
          struct: logic
          type: uni
          act: req
          width: 1
          default: 1'b0
          inst_name: mbx1
          package: ""
          external: true
          conn_type: false
          index: -1
          top_signame: mbx1_doe_intr_support
        }
        {
          name: doe_intr_en
          struct: logic
          type: uni
          act: req
          width: 1
          default: 1'b0
          inst_name: mbx1
          package: ""
          external: true
          conn_type: false
          index: -1
          top_signame: mbx1_doe_intr_en
        }
        {
          name: doe_intr
          struct: logic
          type: uni
          act: req
          width: 1
          default: 1'b0
          inst_name: mbx1
          package: ""
          external: true
          conn_type: false
          index: -1
          top_signame: mbx1_doe_intr
        }
        {
          name: doe_async_msg_support
          struct: logic
          type: uni
          act: req
          width: 1
          default: 1'b0
          inst_name: mbx1
          package: ""
          external: true
          conn_type: false
          index: -1
          top_signame: mbx1_doe_async_msg_support
        }
        {
          name: racl_policies
          desc:
            '''
            Incoming RACL policy vector from a racl_ctrl instance.
            The policy selection vector (parameter) selects the policy for each register.
            '''
          struct: racl_policy_vec
          package: top_racl_pkg
          type: uni
          act: rcv
          width: 1
          inst_name: mbx1
          index: -1
        }
        {
          name: racl_error
          desc: RACL error log information of this module.
          struct: racl_error_log
          package: top_racl_pkg
          type: uni
          act: req
          width: 1
          inst_name: mbx1
          index: -1
        }
        {
          name: sram_tl_h
          struct: tl
          package: tlul_pkg
          type: req_rsp
          act: req
          width: 1
          inst_name: mbx1
          default: ""
          domain: Main
          top_signame: main_tl_mbx1__sram
          index: -1
        }
        {
          name: core_tl_d
          struct: tl
          package: tlul_pkg
          type: req_rsp
          act: rsp
          width: 1
          inst_name: mbx1
          default: ""
          end_idx: -1
          top_type: one-to-one
          top_signame: mbx1_core_tl_d
          index: -1
        }
        {
          name: soc_tl_d
          struct: tl
          package: tlul_pkg
          type: req_rsp
          act: rsp
          width: 1
          inst_name: mbx1
          default: ""
          end_idx: -1
          top_type: one-to-one
          top_signame: mbx1_soc_tl_d
          index: -1
        }
      ]
      generate_dif: true
      domain: Main
    }
    {
      name: rv_core_ibex
      type: rv_core_ibex
      template_type: rv_core_ibex
      attr: ipgen
      ipgen_params:
      {
        num_regions: 32
      }
      param_decl:
      {
        PMPEnable: "1"
        PMPGranularity: "0"
        PMPNumRegions: "16"
        MHPMCounterNum: "10"
        MHPMCounterWidth: "32"
        PMPRstCfg: ibex_pmp_reset_pkg::PmpCfgRst
        PMPRstAddr: ibex_pmp_reset_pkg::PmpAddrRst
        PMPRstMsecCfg: ibex_pmp_reset_pkg::PmpMseccfgRst
        RV32E: "0"
        RV32M: ibex_pkg::RV32MSingleCycle
        RV32B: ibex_pkg::RV32BOTEarlGrey
        RV32ZC: ibex_pkg::RV32ZcaZcbZcmp
        RegFile: ibex_pkg::RegFileFF
        BranchTargetALU: "1"
        WritebackStage: "1"
        ICache: "1"
        ICacheECC: "1"
        ICacheScramble: "1"
        BranchPredictor: "0"
        DbgTriggerEn: "1"
        DbgHwBreakNum: "4"
        SecureIbex: "1"
        DmBaseAddr: tl_main_pkg::ADDR_SPACE_RV_DM__MEM
        DmAddrMask: tl_main_pkg::ADDR_MASK_RV_DM__MEM
        DmHaltAddr: tl_main_pkg::ADDR_SPACE_RV_DM__MEM + dm::HaltAddress[31:0]
        DmExceptionAddr: tl_main_pkg::ADDR_SPACE_RV_DM__MEM + dm::ExceptionAddress[31:0]
        PipeLine: "1"
        InstructionPipeline: "1"
        NEscalationSeverities: AlertHandlerEscNumSeverities
        WidthPingCounter: AlertHandlerEscPingCountWidth
      }
      clock_srcs:
      {
        clk_i: main
        clk_edn_i: main
        clk_esc_i: aon
        clk_otp_i:
        {
          clock: main
          group: secure
        }
      }
      clock_group: secure
      reset_connections:
      {
        rst_ni:
        {
          name: lc_main
          domain: Main
        }
        rst_edn_ni:
        {
          name: lc_main
          domain: Main
        }
        rst_esc_ni:
        {
          name: lc_aon
          domain: Main
        }
        rst_otp_ni:
        {
          name: lc_main
          domain: Main
        }
      }
      clock_connections:
      {
        clk_i: clk_main_i
        clk_edn_i: clk_main_i
        clk_esc_i: clk_aon_i
        clk_otp_i: clk_main_i
      }
      memory: {}
      param_list:
      [
        {
          name: NEscalationSeverities
          desc: Number of escalation severities
          type: int unsigned
          default: AlertHandlerEscNumSeverities
          local: "false"
          expose: "false"
          name_top: RvCoreIbexNEscalationSeverities
        }
        {
          name: WidthPingCounter
          desc: Width of the ping counter
          type: int unsigned
          default: AlertHandlerEscPingCountWidth
          local: "false"
          expose: "false"
          name_top: RvCoreIbexWidthPingCounter
        }
        {
          name: PMPEnable
          desc: Enable PMP
          type: bit
          default: "1"
          local: "false"
          expose: "true"
          name_top: RvCoreIbexPMPEnable
        }
        {
          name: PMPGranularity
          desc: PMP Granularity
          type: int unsigned
          default: "0"
          local: "false"
          expose: "true"
          name_top: RvCoreIbexPMPGranularity
        }
        {
          name: PMPNumRegions
          desc: PMP number of regions
          type: int unsigned
          default: "16"
          local: "false"
          expose: "true"
          name_top: RvCoreIbexPMPNumRegions
        }
        {
          name: MHPMCounterNum
          desc: "Number of the MHPM counter "
          type: int unsigned
          default: "10"
          local: "false"
          expose: "true"
          name_top: RvCoreIbexMHPMCounterNum
        }
        {
          name: MHPMCounterWidth
          desc: "Width of the MHPM Counter "
          type: int unsigned
          default: "32"
          local: "false"
          expose: "true"
          name_top: RvCoreIbexMHPMCounterWidth
        }
        {
          name: PMPRstCfg
          desc: Reset value of PMP config CSRs
          type: ibex_pkg::pmp_cfg_t
          unpacked_dimensions: "[16]"
          default: ibex_pmp_reset_pkg::PmpCfgRst
          local: "false"
          expose: "true"
          name_top: RvCoreIbexPMPRstCfg
        }
        {
          name: PMPRstAddr
          desc: Reset value of PMP address CSRs
          type: logic [33:0]
          unpacked_dimensions: "[16]"
          default: ibex_pmp_reset_pkg::PmpAddrRst
          local: "false"
          expose: "true"
          name_top: RvCoreIbexPMPRstAddr
        }
        {
          name: PMPRstMsecCfg
          desc: Reset value of MSECCFG CSR
          type: ibex_pkg::pmp_mseccfg_t
          default: ibex_pmp_reset_pkg::PmpMseccfgRst
          local: "false"
          expose: "true"
          name_top: RvCoreIbexPMPRstMsecCfg
        }
        {
          name: RV32E
          desc: RV32E
          type: bit
          default: "0"
          local: "false"
          expose: "true"
          name_top: RvCoreIbexRV32E
        }
        {
          name: RV32M
          desc: RV32M
          type: ibex_pkg::rv32m_e
          default: ibex_pkg::RV32MSingleCycle
          local: "false"
          expose: "true"
          name_top: RvCoreIbexRV32M
        }
        {
          name: RV32B
          desc: RV32B
          type: ibex_pkg::rv32b_e
          default: ibex_pkg::RV32BOTEarlGrey
          local: "false"
          expose: "true"
          name_top: RvCoreIbexRV32B
        }
        {
          name: RV32ZC
          desc: RV32ZC
          type: ibex_pkg::rv32zc_e
          default: ibex_pkg::RV32ZcaZcbZcmp
          local: "false"
          expose: "true"
          name_top: RvCoreIbexRV32ZC
        }
        {
          name: RegFile
          desc: Reg file
          type: ibex_pkg::regfile_e
          default: ibex_pkg::RegFileFF
          local: "false"
          expose: "true"
          name_top: RvCoreIbexRegFile
        }
        {
          name: BranchTargetALU
          desc: Branch target ALU
          type: bit
          default: "1"
          local: "false"
          expose: "true"
          name_top: RvCoreIbexBranchTargetALU
        }
        {
          name: WritebackStage
          desc: Write back stage
          type: bit
          default: "1"
          local: "false"
          expose: "true"
          name_top: RvCoreIbexWritebackStage
        }
        {
          name: ICache
          desc: Instruction cache
          type: bit
          default: "1"
          local: "false"
          expose: "true"
          name_top: RvCoreIbexICache
        }
        {
          name: ICacheECC
          desc: Instruction cache ECC
          type: bit
          default: "1"
          local: "false"
          expose: "true"
          name_top: RvCoreIbexICacheECC
        }
        {
          name: ICacheScramble
          desc: Scramble instruction cach
          type: bit
          default: "1"
          local: "false"
          expose: "true"
          name_top: RvCoreIbexICacheScramble
        }
        {
          name: ICacheNWays
          desc: Number of instruction cache ways
          type: int unsigned
          default: 2
          local: "false"
          expose: "true"
          name_top: RvCoreIbexICacheNWays
        }
        {
          name: BranchPredictor
          desc: Branch predictor
          type: bit
          default: "0"
          local: "false"
          expose: "true"
          name_top: RvCoreIbexBranchPredictor
        }
        {
          name: DbgTriggerEn
          desc: Enable degug trigger
          type: bit
          default: "1"
          local: "false"
          expose: "true"
          name_top: RvCoreIbexDbgTriggerEn
        }
        {
          name: DbgHwBreakNum
          desc: Number of debug hardware break
          type: int
          default: "4"
          local: "false"
          expose: "true"
          name_top: RvCoreIbexDbgHwBreakNum
        }
        {
          name: SecureIbex
          desc: "Width of the MHPM Counter "
          type: bit
          default: "1"
          local: "false"
          expose: "true"
          name_top: RvCoreIbexSecureIbex
        }
        {
          name: DmBaseAddr
          desc: Base address of Debug Module
          type: int unsigned
          default: tl_main_pkg::ADDR_SPACE_RV_DM__MEM
          local: "false"
          expose: "true"
          name_top: RvCoreIbexDmBaseAddr
        }
        {
          name: DmAddrMask
          desc: Adress mask of Debug Module
          type: int unsigned
          default: tl_main_pkg::ADDR_MASK_RV_DM__MEM
          local: "false"
          expose: "true"
          name_top: RvCoreIbexDmAddrMask
        }
        {
          name: DmHaltAddr
          desc: Halt address
          type: int unsigned
          default: tl_main_pkg::ADDR_SPACE_RV_DM__MEM + dm::HaltAddress[31:0]
          local: "false"
          expose: "true"
          name_top: RvCoreIbexDmHaltAddr
        }
        {
          name: DmExceptionAddr
          desc: Exception address
          type: int unsigned
          default: tl_main_pkg::ADDR_SPACE_RV_DM__MEM + dm::ExceptionAddress[31:0]
          local: "false"
          expose: "true"
          name_top: RvCoreIbexDmExceptionAddr
        }
        {
          name: PipeLine
          desc: Pipe line
          type: bit
          default: "1"
          local: "false"
          expose: "true"
          name_top: RvCoreIbexPipeLine
        }
        {
          name: TlulHostUserRsvdBits
          desc: TLUL user bits sent on outgoing transfers.
          type: logic [tlul_pkg::RsvdWidth-1:0]
          default: "'0"
          local: "false"
          expose: "true"
          name_top: RvCoreIbexTlulHostUserRsvdBits
        }
        {
          name: CsrMvendorId
          desc:
            '''
            mvendorid: encoding of manufacturer/provider
            0 indicates this field is not implemented.
            Ibex implementors may wish to set their own JEDEC ID here.
            '''
          type: logic [31:0]
          default: "'0"
          local: "false"
          expose: "true"
          name_top: RvCoreIbexCsrMvendorId
        }
        {
          name: CsrMimpId
          desc:
            '''
            mimpid: encoding of processor implementation version
            0 indicates this field is not implemented.
            Ibex implementors may wish to indicate an RTL/netlist version here using their own unique encoding (e.g. 32 bits of the git hash of the implemented commit).
            '''
          type: logic [31:0]
          default: "'0"
          local: "false"
          expose: "true"
          name_top: RvCoreIbexCsrMimpId
        }
        {
          name: InstructionPipeline
          desc: Add a pipeline stage in the instruction interface between Ibex and the address translation
          type: bit
          default: "1"
          local: "true"
          expose: "true"
          name_top: RvCoreIbexInstructionPipeline
        }
      ]
      inter_signal_list:
      [
        {
          name: rst_cpu_n
          struct: logic
          type: uni
          act: req
          width: 1
          inst_name: rv_core_ibex
          index: -1
        }
        {
          name: ram_cfg_icache_tag
          struct: ram_1p_cfg
          package: prim_ram_1p_pkg
          type: req_rsp
          act: rsp
          width:
          {
            name: ICacheNWays
            desc: Number of instruction cache ways
            param_type: int unsigned
            unpacked_dimensions: null
            default: 2
            local: false
            expose: true
            name_top: RvCoreIbexICacheNWays
          }
          inst_name: rv_core_ibex
          index: -1
        }
        {
          name: ram_cfg_icache_data
          struct: ram_1p_cfg
          package: prim_ram_1p_pkg
          type: req_rsp
          act: rsp
          width:
          {
            name: ICacheNWays
            desc: Number of instruction cache ways
            param_type: int unsigned
            unpacked_dimensions: null
            default: 2
            local: false
            expose: true
            name_top: RvCoreIbexICacheNWays
          }
          inst_name: rv_core_ibex
          index: -1
        }
        {
          name: hart_id
          struct: logic
          type: uni
          act: rcv
          width: 32
          inst_name: rv_core_ibex
          default: ""
          package: ""
          top_signame: rv_core_ibex_hart_id
          index: -1
        }
        {
          name: boot_addr
          struct: logic
          type: uni
          act: rcv
          width: 32
          inst_name: rv_core_ibex
          default: ""
          package: ""
          top_signame: rv_core_ibex_boot_addr
          index: -1
        }
        {
          name: irq_software
          struct: logic
          type: uni
          act: rcv
          width: 1
          inst_name: rv_core_ibex
          default: ""
          package: ""
          domain: Main
          top_signame: rv_plic_msip
          index: -1
        }
        {
          name: irq_timer
          struct: logic
          type: uni
          act: rcv
          width: 1
          inst_name: rv_core_ibex
          default: ""
          package: ""
          top_signame: rv_core_ibex_irq_timer
          index: -1
        }
        {
          name: irq_external
          struct: logic
          type: uni
          act: rcv
          width: 1
          inst_name: rv_core_ibex
          default: ""
          package: ""
          domain: Main
          top_signame: rv_plic_irq
          index: -1
        }
        {
          name: esc_tx
          struct: esc_tx
          package: prim_esc_pkg
          type: uni
          act: rcv
          width: 1
          inst_name: rv_core_ibex
          default: ""
          domain: Main
          top_signame: alert_handler_esc_tx
          index: 0
          external: true
          conn_type: false
        }
        {
          name: esc_rx
          struct: esc_rx
          package: prim_esc_pkg
          type: uni
          act: req
          width: 1
          inst_name: rv_core_ibex
          default: ""
          domain: Main
          top_signame: alert_handler_esc_rx
          index: 0
          external: true
          conn_type: false
        }
        {
          name: debug_req
          struct: logic
          type: uni
          act: rcv
          width: 1
          inst_name: rv_core_ibex
          default: ""
          package: ""
          domain: Main
          top_signame: rv_dm_debug_req
          index: -1
        }
        {
          name: crash_dump
          struct: cpu_crash_dump
          package: rv_core_ibex_pkg
          type: uni
          act: req
          width: 1
          inst_name: rv_core_ibex
          default: ""
          end_idx: -1
          top_type: broadcast
          top_signame: rv_core_ibex_crash_dump
          index: -1
          external: true
          conn_type: false
        }
        {
          name: lc_cpu_en
          struct: lc_tx
          package: lc_ctrl_pkg
          type: uni
          act: rcv
          width: 1
          default: lc_ctrl_pkg::On
          inst_name: rv_core_ibex
          domain: Main
          top_signame: lc_ctrl_lc_cpu_en
          index: -1
        }
        {
          name: pwrmgr_cpu_en
          struct: lc_tx
          package: lc_ctrl_pkg
          type: uni
          act: rcv
          width: 1
          inst_name: rv_core_ibex
          default: ""
          domain: Main
          top_signame: pwrmgr_fetch_en
          index: -1
          external: true
          conn_type: false
        }
        {
          name: pwrmgr
          struct: cpu_pwrmgr
          package: rv_core_ibex_pkg
          type: uni
          act: req
          width: 1
          inst_name: rv_core_ibex
          default: ""
          end_idx: -1
          top_type: broadcast
          top_signame: rv_core_ibex_pwrmgr
          index: -1
          external: true
          conn_type: false
        }
        {
          name: nmi_wdog
          struct: logic
          type: uni
          act: rcv
          width: 1
          inst_name: rv_core_ibex
          index: -1
        }
        {
          name: edn
          struct: edn
          package: edn_pkg
          type: req_rsp
          act: req
          width: 1
          inst_name: rv_core_ibex
          default: ""
          domain: Main
          top_signame: edn0_edn
          index: 6
        }
        {
          name: icache_otp_key
          struct: sram_otp_key
          package: otp_ctrl_pkg
          type: req_rsp
          act: req
          width: 1
          inst_name: rv_core_ibex
          default: ""
          domain: Main
          top_signame: otp_ctrl_sram_otp_key
          index: 2
        }
        {
          name: fpga_info
          struct: logic
          type: uni
          act: rcv
          width: 32
          inst_name: rv_core_ibex
          index: -1
        }
        {
          name: corei_tl_h
          struct: tl
          package: tlul_pkg
          type: req_rsp
          act: req
          width: 1
          inst_name: rv_core_ibex
          default: ""
          domain: Main
          top_signame: main_tl_rv_core_ibex__corei
          index: -1
        }
        {
          name: cored_tl_h
          struct: tl
          package: tlul_pkg
          type: req_rsp
          act: req
          width: 1
          inst_name: rv_core_ibex
          default: ""
          domain: Main
          top_signame: main_tl_rv_core_ibex__cored
          index: -1
        }
        {
          name: cfg_tl_d
          struct: tl
          package: tlul_pkg
          type: req_rsp
          act: rsp
          width: 1
          inst_name: rv_core_ibex
          default: ""
          end_idx: -1
          top_type: one-to-one
          top_signame: rv_core_ibex_cfg_tl_d
          index: -1
        }
      ]
      base_addrs:
      {
        cfg:
        {
          hart: 0x211f0000
        }
      }
      generate_dif: true
      domain: Main
    }
  ]
  port: []
  inter_module:
  {
    connect:
    {
      pwrmgr.pwr_rst:
      [
        rstmgr.pwr
      ]
      pwrmgr.pwr_clk:
      [
        clkmgr.pwr
      ]
      pwrmgr.pwr_otp:
      [
        otp_ctrl.pwr_otp
      ]
      pwrmgr.pwr_lc:
      [
        lc_ctrl.pwr_lc
      ]
      pwrmgr.strap:
      [
        rv_dm.strap_en
      ]
      pwrmgr.fetch_en:
      [
        rv_core_ibex.pwrmgr_cpu_en
      ]
      pwrmgr.rom_ctrl:
      [
        rom_ctrl.pwrmgr_data
      ]
      pwrmgr.low_power: []
      pwrmgr.rstreqs: []
      clkmgr.idle: []
      dma.sys: []
      dma.lsio_trigger: []
      alert_handler.esc_rx:
      [
        rv_core_ibex.esc_rx
        lc_ctrl.esc_scrap_state0_rx
        lc_ctrl.esc_scrap_state1_rx
        pwrmgr.esc_rst_rx
      ]
      alert_handler.esc_tx:
      [
        rv_core_ibex.esc_tx
        lc_ctrl.esc_scrap_state0_tx
        lc_ctrl.esc_scrap_state1_tx
        pwrmgr.esc_rst_tx
      ]
      alert_handler.crashdump:
      [
        rstmgr.alert_dump
      ]
      csrng.csrng_cmd:
      [
        edn0.csrng_cmd
        edn1.csrng_cmd
      ]
      csrng.entropy_src_hw_if:
      [
        entropy_src.entropy_src_hw_if
      ]
      edn0.edn:
      [
        keymgr_dpe.edn
        otp_ctrl.edn
        kmac.entropy
        alert_handler.edn
        aes.edn
        otbn.edn_urnd
        rv_core_ibex.edn
      ]
      edn1.edn:
      [
        otbn.edn_rnd
      ]
      otp_ctrl.sram_otp_key:
      [
        sram_ctrl_main.sram_otp_key
        sram_ctrl_ret_aon.sram_otp_key
        rv_core_ibex.icache_otp_key
      ]
      otp_ctrl.otbn_otp_key:
      [
        otbn.otbn_otp_key
      ]
      otp_ctrl.keymgr_creator_root_key:
      [
        keymgr_dpe.creator_root_key
      ]
      otp_ctrl.keymgr_creator_seed:
      [
        keymgr_dpe.creator_seed
      ]
      otp_ctrl.keymgr_owner_seed:
      [
        keymgr_dpe.owner_seed
      ]
      otp_ctrl.otp_macro:
      [
        otp_macro.otp
      ]
      keymgr_dpe.rom_digest:
      [
        rom_ctrl.keymgr_data
      ]
      keymgr_dpe.aes_key:
      [
        aes.keymgr_key
      ]
      keymgr_dpe.kmac_key:
      [
        kmac.keymgr_key
      ]
      keymgr_dpe.otbn_key:
      [
        otbn.keymgr_key
      ]
      kmac.app:
      [
        keymgr_dpe.kmac_data
        lc_ctrl.kmac_data
        rom_ctrl.kmac_data
      ]
      kmac.en_masking:
      [
        keymgr_dpe.kmac_en_masking
      ]
      lc_ctrl.lc_nvm_rma_req:
      [
        otbn.lc_rma_req
      ]
      otbn.lc_rma_ack:
      [
        lc_ctrl.lc_nvm_rma_ack
      ]
      lc_ctrl.lc_clk_byp_ack:
      [
        lc_ctrl.lc_clk_byp_req
      ]
      otp_ctrl.otp_lc_data:
      [
        lc_ctrl.otp_lc_data
      ]
      lc_ctrl.lc_otp_program:
      [
        otp_ctrl.lc_otp_program
      ]
      lc_ctrl.lc_otp_vendor_test:
      [
        otp_macro.test
      ]
      lc_ctrl.lc_keymgr_div:
      [
        keymgr_dpe.lc_keymgr_div
      ]
      lc_ctrl.strap_en_override:
      [
        rv_dm.strap_en_override
      ]
      lc_ctrl.lc_dft_en:
      [
        otp_macro.lc_dft_en
        pwrmgr.lc_dft_en
        rv_dm.lc_dft_en
      ]
      lc_ctrl.lc_hw_debug_clr:
      [
        rv_dm.lc_hw_debug_clr
      ]
      lc_ctrl.lc_init_done:
      [
        rv_dm.lc_init_done
      ]
      lc_ctrl.lc_hw_debug_en:
      [
        sram_ctrl_main.lc_hw_debug_en
        sram_ctrl_ret_aon.lc_hw_debug_en
        csrng.lc_hw_debug_en
        rv_dm.lc_hw_debug_en
        pwrmgr.lc_hw_debug_en
      ]
      lc_ctrl.lc_cpu_en:
      [
        rv_core_ibex.lc_cpu_en
      ]
      lc_ctrl.lc_keymgr_en:
      [
        keymgr_dpe.lc_keymgr_en
      ]
      lc_ctrl.lc_escalate_en:
      [
        aes.lc_escalate_en
        kmac.lc_escalate_en
        otbn.lc_escalate_en
        otp_ctrl.lc_escalate_en
        sram_ctrl_main.lc_escalate_en
        sram_ctrl_ret_aon.lc_escalate_en
        rv_dm.lc_escalate_en
      ]
      lc_ctrl.lc_check_byp_en:
      [
        otp_ctrl.lc_check_byp_en
        rv_dm.lc_check_byp_en
      ]
      lc_ctrl.lc_raw_test_rma: []
      lc_ctrl.lc_creator_seed_sw_rw_en:
      [
        otp_ctrl.lc_creator_seed_sw_rw_en
      ]
      lc_ctrl.lc_owner_seed_sw_rw_en:
      [
        otp_ctrl.lc_owner_seed_sw_rw_en
      ]
      lc_ctrl.lc_seed_hw_rd_en:
      [
        otp_ctrl.lc_seed_hw_rd_en
      ]
      lc_ctrl.lc_rma_state:
      [
        otp_ctrl.lc_rma_state
      ]
      rv_plic.msip:
      [
        rv_core_ibex.irq_software
      ]
      rv_plic.irq:
      [
        rv_core_ibex.irq_external
      ]
      rv_dm.debug_req:
      [
        rv_core_ibex.debug_req
      ]
      rv_core_ibex.crash_dump:
      [
        rstmgr.cpu_dump
      ]
      rv_core_ibex.pwrmgr:
      [
        pwrmgr.pwr_cpu
      ]
      rv_dm.ndmreset_req:
      [
        pwrmgr.ndmreset_req
      ]
      rstmgr.sw_rst_req:
      [
        pwrmgr.sw_rst_req
      ]
      main.tl_rv_core_ibex__corei:
      [
        rv_core_ibex.corei_tl_h
      ]
      main.tl_rv_core_ibex__cored:
      [
        rv_core_ibex.cored_tl_h
      ]
      main.tl_rv_dm__sba:
      [
        rv_dm.sba_tl_h
      ]
      main.tl_dma__host:
      [
        dma.host_tl_h
      ]
      main.tl_mbx0__sram:
      [
        mbx0.sram_tl_h
      ]
      main.tl_mbx1__sram:
      [
        mbx1.sram_tl_h
      ]
      rv_dm.regs_tl_d:
      [
        main.tl_rv_dm__regs
      ]
      rv_dm.mem_tl_d:
      [
        main.tl_rv_dm__mem
      ]
      rom_ctrl.rom_tl:
      [
        main.tl_rom_ctrl__rom
      ]
      rom_ctrl.regs_tl:
      [
        main.tl_rom_ctrl__regs
      ]
      sram_ctrl_main.regs_tl:
      [
        main.tl_sram_ctrl_main__regs
      ]
      sram_ctrl_main.ram_tl:
      [
        main.tl_sram_ctrl_main__ram
      ]
      otp_ctrl.core_tl:
      [
        main.tl_otp_ctrl__core
      ]
      otp_macro.prim_tl:
      [
        main.tl_otp_macro__prim
      ]
      lc_ctrl.regs_tl:
      [
        main.tl_lc_ctrl__regs
      ]
      rv_plic.tl:
      [
        main.tl_rv_plic
      ]
      rv_timer.tl:
      [
        main.tl_rv_timer
      ]
      aes.tl:
      [
        main.tl_aes
      ]
      hmac.tl:
      [
        main.tl_hmac
      ]
      kmac.tl:
      [
        main.tl_kmac
      ]
      otbn.tl:
      [
        main.tl_otbn
      ]
      keymgr_dpe.tl:
      [
        main.tl_keymgr_dpe
      ]
      csrng.tl:
      [
        main.tl_csrng
      ]
      entropy_src.tl:
      [
        main.tl_entropy_src
      ]
      edn0.tl:
      [
        main.tl_edn0
      ]
      edn1.tl:
      [
        main.tl_edn1
      ]
      rv_core_ibex.cfg_tl_d:
      [
        main.tl_rv_core_ibex__cfg
      ]
      dma.tl_d:
      [
        main.tl_dma
      ]
      ahb_bridge.ctn_tl_d:
      [
        main.tl_ahb_bridge__ctn
      ]
      mbx0.core_tl_d:
      [
        main.tl_mbx0__core
      ]
      mbx1.core_tl_d:
      [
        main.tl_mbx1__core
      ]
      main.tl_aon:
      [
        aon.tl_main
      ]
      pwrmgr.tl:
      [
        aon.tl_pwrmgr
      ]
      rstmgr.tl:
      [
        aon.tl_rstmgr
      ]
      clkmgr.tl:
      [
        aon.tl_clkmgr
      ]
      alert_handler.tl:
      [
        aon.tl_alert_handler
      ]
      rv_timer_aon.tl:
      [
        aon.tl_rv_timer_aon
      ]
      sram_ctrl_ret_aon.regs_tl:
      [
        aon.tl_sram_ctrl_ret_aon__regs
      ]
      sram_ctrl_ret_aon.ram_tl:
      [
        aon.tl_sram_ctrl_ret_aon__ram
      ]
      socmbx.tl_ahb_bridge__socmbx:
      [
        ahb_bridge.socmbx_tl_h
      ]
      mbx0.soc_tl_d:
      [
        socmbx.tl_mbx0__soc
      ]
      mbx1.soc_tl_d:
      [
        socmbx.tl_mbx1__soc
      ]
      lc_ctrl.dmi_tl:
      [
        socdbg.tl_lc_ctrl__dmi
      ]
      rv_dm.dbg_tl_d:
      [
        socdbg.tl_rv_dm__dbg
      ]
    }
    top:
    [
      clkmgr.clocks
      clkmgr.cg_en
      rstmgr.resets
      rstmgr.rst_en
      rstmgr.por_n
      pwrmgr.pwr_ast
      lc_ctrl.lc_nvm_debug_en
      rv_core_ibex.irq_timer
      rv_core_ibex.hart_id
      rv_core_ibex.boot_addr
      otp_ctrl.otp_broadcast
      csrng.otp_en_csrng_sw_app_read
      lc_ctrl.otp_device_id
      lc_ctrl.otp_manuf_state
      keymgr_dpe.device_id
      sram_ctrl_main.otp_en_sram_ifetch
      rv_dm.otp_dis_rv_dm_late_debug
    ]
    external:
    {
      pwrmgr.wakeups: wakeup_main
      entropy_src.entropy_src_rng_enable: es_rng_enable
      entropy_src.entropy_src_rng_valid: es_rng_valid
      entropy_src.entropy_src_rng_bits: es_rng_bit
      entropy_src.rng_fips: es_rng_fips
      mbx0.doe_intr: mbx0_doe_intr
      mbx0.doe_intr_en: mbx0_doe_intr_en
      mbx0.doe_intr_support: mbx0_doe_intr_support
      mbx0.doe_async_msg_support: mbx0_doe_async_msg_support
      mbx1.doe_intr: mbx1_doe_intr
      mbx1.doe_intr_en: mbx1_doe_intr_en
      mbx1.doe_intr_support: mbx1_doe_intr_support
      mbx1.doe_async_msg_support: mbx1_doe_async_msg_support
      ahb_bridge.ahb_mgr_m2s: soc_mgr_ahb_req
      ahb_bridge.ahb_mgr_s2m: soc_mgr_ahb_rsp
      ahb_bridge.ahb_sub_m2s: soc_mbx_ahb_req
      ahb_bridge.ahb_sub_s2m: soc_mbx_ahb_rsp
      socdbg.tl_ext_socdbg_host: soc_dbg_tl
    }
  }
  xbar:
  [
    {
      name: main
      clock_srcs:
      {
        clk_main_i: main
        clk_aon_i: aon
      }
      clock_group: secure
      reset: rst_main_ni
      reset_connections:
      {
        rst_main_ni:
        {
          name: lc_main
          domain: Main
        }
        rst_aon_ni:
        {
          name: lc_aon
          domain: Main
        }
      }
      clock_connections:
      {
        clk_main_i: clk_main_i
        clk_aon_i: clk_aon_i
      }
      domain: Main
      connections:
      {
        rv_core_ibex.corei:
        [
          rv_dm.mem
          rom_ctrl.rom
          rom_ctrl.regs
          sram_ctrl_main.ram
        ]
        rv_core_ibex.cored:
        [
          rv_dm.regs
          rv_dm.mem
          rom_ctrl.rom
          rom_ctrl.regs
          sram_ctrl_main.regs
          sram_ctrl_main.ram
          otp_ctrl.core
          otp_macro.prim
          lc_ctrl.regs
          rv_plic
          rv_timer
          aes
          hmac
          kmac
          otbn
          keymgr_dpe
          csrng
          entropy_src
          edn0
          edn1
          rv_core_ibex.cfg
          dma
          ahb_bridge.ctn
          mbx0.core
          mbx1.core
          aon
        ]
        rv_dm.sba:
        [
          rv_dm.regs
          rom_ctrl.rom
          rom_ctrl.regs
          sram_ctrl_main.regs
          sram_ctrl_main.ram
          otp_ctrl.core
          otp_macro.prim
          lc_ctrl.regs
          rv_plic
          rv_timer
          aes
          hmac
          kmac
          otbn
          keymgr_dpe
          csrng
          entropy_src
          edn0
          edn1
          rv_core_ibex.cfg
          dma
          mbx0.core
          mbx1.core
          aon
        ]
        dma.host:
        [
          sram_ctrl_main.ram
          rom_ctrl.rom
          ahb_bridge.ctn
        ]
        mbx0.sram:
        [
          sram_ctrl_main.ram
        ]
        mbx1.sram:
        [
          sram_ctrl_main.ram
        ]
      }
      nodes:
      [
        {
          name: rv_core_ibex.corei
          type: host
          addr_space: hart
          clock: clk_main_i
          reset: rst_main_ni
          pipeline: false
          xbar: false
          stub: false
          inst_type: ""
          req_fifo_pass: true
          rsp_fifo_pass: true
        }
        {
          name: rv_core_ibex.cored
          type: host
          addr_space: hart
          clock: clk_main_i
          reset: rst_main_ni
          pipeline: false
          xbar: false
          stub: false
          inst_type: ""
          req_fifo_pass: true
          rsp_fifo_pass: true
        }
        {
          name: rv_dm.sba
          type: host
          addr_space: hart
          clock: clk_main_i
          reset: rst_main_ni
          pipeline: false
          xbar: false
          stub: false
          inst_type: ""
          req_fifo_pass: true
          rsp_fifo_pass: true
        }
        {
          name: dma.host
          type: host
          addr_space: hart
          clock: clk_main_i
          reset: rst_main_ni
          pipeline: false
          xbar: false
          stub: false
          inst_type: ""
          req_fifo_pass: true
          rsp_fifo_pass: true
        }
        {
          name: mbx0.sram
          type: host
          addr_space: hart
          clock: clk_main_i
          reset: rst_main_ni
          pipeline: false
          xbar: false
          stub: false
          inst_type: ""
          req_fifo_pass: true
          rsp_fifo_pass: true
        }
        {
          name: mbx1.sram
          type: host
          addr_space: hart
          clock: clk_main_i
          reset: rst_main_ni
          pipeline: false
          xbar: false
          stub: false
          inst_type: ""
          req_fifo_pass: true
          rsp_fifo_pass: true
        }
        {
          name: rv_dm.regs
          type: device
          clock: clk_main_i
          reset: rst_main_ni
          pipeline: false
          inst_type: rv_dm
          addr_range:
          [
            {
              base_addrs:
              {
                hart: 0x21200000
              }
              size_byte: 0x10
            }
          ]
          xbar: false
          stub: false
          req_fifo_pass: true
        }
        {
          name: rv_dm.mem
          type: device
          clock: clk_main_i
          reset: rst_main_ni
          pipeline: false
          inst_type: rv_dm
          addr_range:
          [
            {
              base_addrs:
              {
                hart: 0x50000
              }
              size_byte: 0x1000
            }
          ]
          xbar: false
          stub: false
          req_fifo_pass: true
        }
        {
          name: rom_ctrl.rom
          type: device
          clock: clk_main_i
          reset: rst_main_ni
          pipeline: false
          inst_type: rom_ctrl
          addr_range:
          [
            {
              base_addrs:
              {
                hart: 0x20000
              }
              size_byte: 0x20000
            }
          ]
          xbar: false
          stub: false
          req_fifo_pass: true
        }
        {
          name: rom_ctrl.regs
          type: device
          clock: clk_main_i
          reset: rst_main_ni
          pipeline: false
          inst_type: rom_ctrl
          addr_range:
          [
            {
              base_addrs:
              {
                hart: 0x211e0000
              }
              size_byte: 0x80
            }
          ]
          xbar: false
          stub: false
          req_fifo_pass: true
        }
        {
          name: sram_ctrl_main.regs
          type: device
          clock: clk_main_i
          reset: rst_main_ni
          pipeline: false
          inst_type: sram_ctrl
          addr_range:
          [
            {
              base_addrs:
              {
                hart: 0x211c0000
              }
              size_byte: 0x40
            }
          ]
          xbar: false
          stub: false
          req_fifo_pass: true
        }
        {
          name: sram_ctrl_main.ram
          type: device
          clock: clk_main_i
          reset: rst_main_ni
          pipeline: false
          inst_type: sram_ctrl
          addr_range:
          [
            {
              base_addrs:
              {
                hart: 0x10000000
              }
              size_byte: 0x30000
            }
          ]
          xbar: false
          stub: false
          req_fifo_pass: true
        }
        {
          name: otp_ctrl.core
          type: device
          clock: clk_main_i
          reset: rst_main_ni
          pipeline: false
          inst_type: otp_ctrl
          addr_range:
          [
            {
              base_addrs:
              {
                hart: 0x30130000
              }
              size_byte: 0x4000
            }
          ]
          xbar: false
          stub: false
          req_fifo_pass: true
        }
        {
          name: otp_macro.prim
          type: device
          clock: clk_main_i
          reset: rst_main_ni
          pipeline: false
          inst_type: otp_macro
          addr_range:
          [
            {
              base_addrs:
              {
                hart: 0x30140000
              }
              size_byte: 0x20
            }
          ]
          xbar: false
          stub: false
          req_fifo_pass: true
        }
        {
          name: lc_ctrl.regs
          type: device
          clock: clk_main_i
          reset: rst_main_ni
          pipeline: false
          inst_type: lc_ctrl
          addr_range:
          [
            {
              base_addrs:
              {
                hart: 0x30150000
              }
              size_byte: 0x100
            }
          ]
          xbar: false
          stub: false
          req_fifo_pass: true
        }
        {
          name: rv_plic
          type: device
          clock: clk_main_i
          reset: rst_main_ni
          pipeline: false
          inst_type: rv_plic
          addr_range:
          [
            {
              base_addrs:
              {
                hart: 0x28000000
              }
              size_byte: 0x8000000
            }
          ]
          xbar: false
          stub: false
          req_fifo_pass: true
        }
        {
          name: rv_timer
          type: device
          clock: clk_main_i
          reset: rst_main_ni
          pipeline: false
          inst_type: rv_timer
          addr_range:
          [
            {
              base_addrs:
              {
                hart: 0x21190000
              }
              size_byte: 0x200
            }
          ]
          xbar: false
          stub: false
          req_fifo_pass: true
        }
        {
          name: aes
          type: device
          clock: clk_main_i
          reset: rst_main_ni
          pipeline: false
          inst_type: aes
          addr_range:
          [
            {
              base_addrs:
              {
                hart: 0x21100000
              }
              size_byte: 0x100
            }
          ]
          xbar: false
          stub: false
          req_fifo_pass: true
        }
        {
          name: hmac
          type: device
          clock: clk_main_i
          reset: rst_main_ni
          pipeline: false
          inst_type: hmac
          addr_range:
          [
            {
              base_addrs:
              {
                hart: 0x21110000
              }
              size_byte: 0x2000
            }
          ]
          xbar: false
          stub: false
          req_fifo_pass: true
        }
        {
          name: kmac
          type: device
          clock: clk_main_i
          reset: rst_main_ni
          pipeline: false
          inst_type: kmac
          addr_range:
          [
            {
              base_addrs:
              {
                hart: 0x21120000
              }
              size_byte: 0x1000
            }
          ]
          xbar: false
          stub: false
          req_fifo_pass: true
        }
        {
          name: otbn
          type: device
          clock: clk_main_i
          reset: rst_main_ni
          pipeline: false
          inst_type: otbn
          addr_range:
          [
            {
              base_addrs:
              {
                hart: 0x21130000
              }
              size_byte: 0x10000
            }
          ]
          xbar: false
          stub: false
          req_fifo_pass: true
        }
        {
          name: keymgr_dpe
          type: device
          clock: clk_main_i
          reset: rst_main_ni
          pipeline: false
          inst_type: keymgr_dpe
          addr_range:
          [
            {
              base_addrs:
              {
                hart: 0x21140000
              }
              size_byte: 0x100
            }
          ]
          xbar: false
          stub: false
          req_fifo_pass: true
        }
        {
          name: csrng
          type: device
          clock: clk_main_i
          reset: rst_main_ni
          pipeline: false
          inst_type: csrng
          addr_range:
          [
            {
              base_addrs:
              {
                hart: 0x21150000
              }
              size_byte: 0x80
            }
          ]
          xbar: false
          stub: false
          req_fifo_pass: true
        }
        {
          name: entropy_src
          type: device
          clock: clk_main_i
          reset: rst_main_ni
          pipeline: false
          inst_type: entropy_src
          addr_range:
          [
            {
              base_addrs:
              {
                hart: 0x21160000
              }
              size_byte: 0x100
            }
          ]
          xbar: false
          stub: false
          req_fifo_pass: true
        }
        {
          name: edn0
          type: device
          clock: clk_main_i
          reset: rst_main_ni
          pipeline: false
          inst_type: edn
          addr_range:
          [
            {
              base_addrs:
              {
                hart: 0x21170000
              }
              size_byte: 0x80
            }
          ]
          xbar: false
          stub: false
          req_fifo_pass: true
        }
        {
          name: edn1
          type: device
          clock: clk_main_i
          reset: rst_main_ni
          pipeline: false
          inst_type: edn
          addr_range:
          [
            {
              base_addrs:
              {
                hart: 0x21180000
              }
              size_byte: 0x80
            }
          ]
          xbar: false
          stub: false
          req_fifo_pass: true
        }
        {
          name: rv_core_ibex.cfg
          type: device
          clock: clk_main_i
          reset: rst_main_ni
          pipeline: false
          inst_type: rv_core_ibex
          addr_range:
          [
            {
              base_addrs:
              {
                hart: 0x211f0000
              }
              size_byte: 0x800
            }
          ]
          xbar: false
          stub: false
          req_fifo_pass: true
        }
        {
          name: dma
          type: device
          clock: clk_main_i
          reset: rst_main_ni
          pipeline: false
          inst_type: dma
          addr_range:
          [
            {
              base_addrs:
              {
                hart: 0x22010000
              }
              size_byte: 0x200
            }
          ]
          xbar: false
          stub: false
          req_fifo_pass: true
        }
        {
          name: ahb_bridge.ctn
          type: device
          clock: clk_main_i
          reset: rst_main_ni
          pipeline: false
          inst_type: ahb_bridge
          addr_range:
          [
            {
              base_addrs:
              {
                hart: 0x80000000
              }
              size_byte: 0x10000000
            }
          ]
          xbar: false
          stub: false
          req_fifo_pass: true
        }
        {
          name: mbx0.core
          type: device
          clock: clk_main_i
          reset: rst_main_ni
          pipeline: false
          inst_type: mbx
          addr_range:
          [
            {
              base_addrs:
              {
                hart: 0x22000000
              }
              size_byte: 0x80
            }
          ]
          xbar: false
          stub: false
          req_fifo_pass: true
        }
        {
          name: mbx1.core
          type: device
          clock: clk_main_i
          reset: rst_main_ni
          pipeline: false
          inst_type: mbx
          addr_range:
          [
            {
              base_addrs:
              {
                hart: 0x22000100
              }
              size_byte: 0x80
            }
          ]
          xbar: false
          stub: false
          req_fifo_pass: true
        }
        {
          name: aon
          type: device
          clock: clk_aon_i
          reset: rst_aon_ni
          pipeline: false
          xbar: true
          stub: false
          req_fifo_pass: true
          addr_space: hart
          addr_range:
          [
            {
              base_addrs:
              {
                hart: 0x40400000
              }
              size_byte: 0x80000
            }
          ]
        }
      ]
      addr_spaces:
      [
        hart
      ]
      clock: clk_main_i
      type: xbar
      inter_signal_list:
      [
        {
          name: tl_rv_core_ibex__corei
          struct: tl
          package: tlul_pkg
          type: req_rsp
          act: rsp
          inst_name: main
          width: 1
          default: ""
          end_idx: -1
          top_type: one-to-one
          top_signame: main_tl_rv_core_ibex__corei
          index: -1
        }
        {
          name: tl_rv_core_ibex__cored
          struct: tl
          package: tlul_pkg
          type: req_rsp
          act: rsp
          inst_name: main
          width: 1
          default: ""
          end_idx: -1
          top_type: one-to-one
          top_signame: main_tl_rv_core_ibex__cored
          index: -1
        }
        {
          name: tl_rv_dm__sba
          struct: tl
          package: tlul_pkg
          type: req_rsp
          act: rsp
          inst_name: main
          width: 1
          default: ""
          end_idx: -1
          top_type: one-to-one
          top_signame: main_tl_rv_dm__sba
          index: -1
        }
        {
          name: tl_dma__host
          struct: tl
          package: tlul_pkg
          type: req_rsp
          act: rsp
          inst_name: main
          width: 1
          default: ""
          end_idx: -1
          top_type: one-to-one
          top_signame: main_tl_dma__host
          index: -1
        }
        {
          name: tl_mbx0__sram
          struct: tl
          package: tlul_pkg
          type: req_rsp
          act: rsp
          inst_name: main
          width: 1
          default: ""
          end_idx: -1
          top_type: one-to-one
          top_signame: main_tl_mbx0__sram
          index: -1
        }
        {
          name: tl_mbx1__sram
          struct: tl
          package: tlul_pkg
          type: req_rsp
          act: rsp
          inst_name: main
          width: 1
          default: ""
          end_idx: -1
          top_type: one-to-one
          top_signame: main_tl_mbx1__sram
          index: -1
        }
        {
          name: tl_rv_dm__regs
          struct: tl
          package: tlul_pkg
          type: req_rsp
          act: req
          inst_name: main
          width: 1
          default: ""
          domain: Main
          top_signame: rv_dm_regs_tl_d
          index: -1
        }
        {
          name: tl_rv_dm__mem
          struct: tl
          package: tlul_pkg
          type: req_rsp
          act: req
          inst_name: main
          width: 1
          default: ""
          domain: Main
          top_signame: rv_dm_mem_tl_d
          index: -1
        }
        {
          name: tl_rom_ctrl__rom
          struct: tl
          package: tlul_pkg
          type: req_rsp
          act: req
          inst_name: main
          width: 1
          default: ""
          domain: Main
          top_signame: rom_ctrl_rom_tl
          index: -1
        }
        {
          name: tl_rom_ctrl__regs
          struct: tl
          package: tlul_pkg
          type: req_rsp
          act: req
          inst_name: main
          width: 1
          default: ""
          domain: Main
          top_signame: rom_ctrl_regs_tl
          index: -1
        }
        {
          name: tl_sram_ctrl_main__regs
          struct: tl
          package: tlul_pkg
          type: req_rsp
          act: req
          inst_name: main
          width: 1
          default: ""
          domain: Main
          top_signame: sram_ctrl_main_regs_tl
          index: -1
        }
        {
          name: tl_sram_ctrl_main__ram
          struct: tl
          package: tlul_pkg
          type: req_rsp
          act: req
          inst_name: main
          width: 1
          default: ""
          domain: Main
          top_signame: sram_ctrl_main_ram_tl
          index: -1
        }
        {
          name: tl_otp_ctrl__core
          struct: tl
          package: tlul_pkg
          type: req_rsp
          act: req
          inst_name: main
          width: 1
          default: ""
          domain: Main
          top_signame: otp_ctrl_core_tl
          index: -1
        }
        {
          name: tl_otp_macro__prim
          struct: tl
          package: tlul_pkg
          type: req_rsp
          act: req
          inst_name: main
          width: 1
          default: ""
          domain: Main
          top_signame: otp_macro_prim_tl
          index: -1
        }
        {
          name: tl_lc_ctrl__regs
          struct: tl
          package: tlul_pkg
          type: req_rsp
          act: req
          inst_name: main
          width: 1
          default: ""
          domain: Main
          top_signame: lc_ctrl_regs_tl
          index: -1
        }
        {
          name: tl_rv_plic
          struct: tl
          package: tlul_pkg
          type: req_rsp
          act: req
          inst_name: main
          width: 1
          default: ""
          domain: Main
          top_signame: rv_plic_tl
          index: -1
        }
        {
          name: tl_rv_timer
          struct: tl
          package: tlul_pkg
          type: req_rsp
          act: req
          inst_name: main
          width: 1
          default: ""
          domain: Main
          top_signame: rv_timer_tl
          index: -1
        }
        {
          name: tl_aes
          struct: tl
          package: tlul_pkg
          type: req_rsp
          act: req
          inst_name: main
          width: 1
          default: ""
          domain: Main
          top_signame: aes_tl
          index: -1
        }
        {
          name: tl_hmac
          struct: tl
          package: tlul_pkg
          type: req_rsp
          act: req
          inst_name: main
          width: 1
          default: ""
          domain: Main
          top_signame: hmac_tl
          index: -1
        }
        {
          name: tl_kmac
          struct: tl
          package: tlul_pkg
          type: req_rsp
          act: req
          inst_name: main
          width: 1
          default: ""
          domain: Main
          top_signame: kmac_tl
          index: -1
        }
        {
          name: tl_otbn
          struct: tl
          package: tlul_pkg
          type: req_rsp
          act: req
          inst_name: main
          width: 1
          default: ""
          domain: Main
          top_signame: otbn_tl
          index: -1
        }
        {
          name: tl_keymgr_dpe
          struct: tl
          package: tlul_pkg
          type: req_rsp
          act: req
          inst_name: main
          width: 1
          default: ""
          domain: Main
          top_signame: keymgr_dpe_tl
          index: -1
        }
        {
          name: tl_csrng
          struct: tl
          package: tlul_pkg
          type: req_rsp
          act: req
          inst_name: main
          width: 1
          default: ""
          domain: Main
          top_signame: csrng_tl
          index: -1
        }
        {
          name: tl_entropy_src
          struct: tl
          package: tlul_pkg
          type: req_rsp
          act: req
          inst_name: main
          width: 1
          default: ""
          domain: Main
          top_signame: entropy_src_tl
          index: -1
        }
        {
          name: tl_edn0
          struct: tl
          package: tlul_pkg
          type: req_rsp
          act: req
          inst_name: main
          width: 1
          default: ""
          domain: Main
          top_signame: edn0_tl
          index: -1
        }
        {
          name: tl_edn1
          struct: tl
          package: tlul_pkg
          type: req_rsp
          act: req
          inst_name: main
          width: 1
          default: ""
          domain: Main
          top_signame: edn1_tl
          index: -1
        }
        {
          name: tl_rv_core_ibex__cfg
          struct: tl
          package: tlul_pkg
          type: req_rsp
          act: req
          inst_name: main
          width: 1
          default: ""
          domain: Main
          top_signame: rv_core_ibex_cfg_tl_d
          index: -1
        }
        {
          name: tl_dma
          struct: tl
          package: tlul_pkg
          type: req_rsp
          act: req
          inst_name: main
          width: 1
          default: ""
          domain: Main
          top_signame: dma_tl_d
          index: -1
        }
        {
          name: tl_ahb_bridge__ctn
          struct: tl
          package: tlul_pkg
          type: req_rsp
          act: req
          inst_name: main
          width: 1
          default: ""
          domain: Main
          top_signame: ahb_bridge_ctn_tl_d
          index: -1
        }
        {
          name: tl_mbx0__core
          struct: tl
          package: tlul_pkg
          type: req_rsp
          act: req
          inst_name: main
          width: 1
          default: ""
          domain: Main
          top_signame: mbx0_core_tl_d
          index: -1
        }
        {
          name: tl_mbx1__core
          struct: tl
          package: tlul_pkg
          type: req_rsp
          act: req
          inst_name: main
          width: 1
          default: ""
          domain: Main
          top_signame: mbx1_core_tl_d
          index: -1
        }
        {
          name: tl_aon
          struct: tl
          package: tlul_pkg
          type: req_rsp
          act: req
          inst_name: main
          width: 1
          default: ""
          end_idx: -1
          top_type: one-to-one
          top_signame: main_tl_aon
          index: -1
          external: true
          conn_type: false
        }
      ]
    }
    {
      name: aon
      domain: Aon
      clock_srcs:
      {
        clk_aon_i: aon
      }
      clock_group: ext
      reset: rst_aon_ni
      reset_connections:
      {
        rst_aon_ni:
        {
          name: lc_aon
          domain: Aon
        }
      }
      clock_connections:
      {
        clk_aon_i: clk_aon_i
      }
      connections:
      {
        main:
        [
          pwrmgr
          rstmgr
          clkmgr
          alert_handler
          rv_timer_aon
          sram_ctrl_ret_aon.regs
          sram_ctrl_ret_aon.ram
        ]
      }
      nodes:
      [
        {
          name: main
          type: host
          addr_space: hart
          clock: clk_aon_i
          reset: rst_aon_ni
          pipeline: false
          xbar: true
          stub: false
          inst_type: ""
          req_fifo_pass: true
          rsp_fifo_pass: true
        }
        {
          name: pwrmgr
          type: device
          clock: clk_aon_i
          reset: rst_aon_ni
          pipeline: false
          inst_type: pwrmgr
          addr_range:
          [
            {
              base_addrs:
              {
                hart: 0x40400000
              }
              size_byte: 0x80
            }
          ]
          xbar: false
          stub: false
          req_fifo_pass: true
        }
        {
          name: rstmgr
          type: device
          clock: clk_aon_i
          reset: rst_aon_ni
          pipeline: false
          inst_type: rstmgr
          addr_range:
          [
            {
              base_addrs:
              {
                hart: 0x40410000
              }
              size_byte: 0x40
            }
          ]
          xbar: false
          stub: false
          req_fifo_pass: true
        }
        {
          name: clkmgr
          type: device
          clock: clk_aon_i
          reset: rst_aon_ni
          pipeline: false
          inst_type: clkmgr
          addr_range:
          [
            {
              base_addrs:
              {
                hart: 0x40420000
              }
              size_byte: 0x40
            }
          ]
          xbar: false
          stub: false
          req_fifo_pass: true
        }
        {
          name: alert_handler
          type: device
          clock: clk_aon_i
          reset: rst_aon_ni
          pipeline: false
          inst_type: alert_handler
          addr_range:
          [
            {
              base_addrs:
              {
                hart: 0x40450000
              }
              size_byte: 0x800
            }
          ]
          xbar: false
          stub: false
          req_fifo_pass: true
        }
        {
          name: rv_timer_aon
          type: device
          clock: clk_aon_i
          reset: rst_aon_ni
          pipeline: false
          inst_type: rv_timer
          addr_range:
          [
            {
              base_addrs:
              {
                hart: 0x40430000
              }
              size_byte: 0x200
            }
          ]
          xbar: false
          stub: false
          req_fifo_pass: true
        }
        {
          name: sram_ctrl_ret_aon.regs
          type: device
          clock: clk_aon_i
          reset: rst_aon_ni
          pipeline: false
          inst_type: sram_ctrl
          addr_range:
          [
            {
              base_addrs:
              {
                hart: 0x40460000
              }
              size_byte: 0x40
            }
          ]
          xbar: false
          stub: false
          req_fifo_pass: true
        }
        {
          name: sram_ctrl_ret_aon.ram
          type: device
          clock: clk_aon_i
          reset: rst_aon_ni
          pipeline: false
          inst_type: sram_ctrl
          addr_range:
          [
            {
              base_addrs:
              {
                hart: 0x40470000
              }
              size_byte: 0x2000
            }
          ]
          xbar: false
          stub: false
          req_fifo_pass: true
        }
      ]
      addr_spaces:
      [
        hart
      ]
      clock: clk_aon_i
      type: xbar
      inter_signal_list:
      [
        {
          name: tl_main
          struct: tl
          package: tlul_pkg
          type: req_rsp
          act: rsp
          inst_name: aon
          width: 1
          default: ""
          domain: Aon
          top_signame: main_tl_aon
          index: -1
          external: true
          conn_type: false
        }
        {
          name: tl_pwrmgr
          struct: tl
          package: tlul_pkg
          type: req_rsp
          act: req
          inst_name: aon
          width: 1
          default: ""
          domain: Aon
          top_signame: pwrmgr_tl
          index: -1
        }
        {
          name: tl_rstmgr
          struct: tl
          package: tlul_pkg
          type: req_rsp
          act: req
          inst_name: aon
          width: 1
          default: ""
          domain: Aon
          top_signame: rstmgr_tl
          index: -1
        }
        {
          name: tl_clkmgr
          struct: tl
          package: tlul_pkg
          type: req_rsp
          act: req
          inst_name: aon
          width: 1
          default: ""
          domain: Aon
          top_signame: clkmgr_tl
          index: -1
        }
        {
          name: tl_alert_handler
          struct: tl
          package: tlul_pkg
          type: req_rsp
          act: req
          inst_name: aon
          width: 1
          default: ""
          domain: Aon
          top_signame: alert_handler_tl
          index: -1
        }
        {
          name: tl_rv_timer_aon
          struct: tl
          package: tlul_pkg
          type: req_rsp
          act: req
          inst_name: aon
          width: 1
          default: ""
          domain: Aon
          top_signame: rv_timer_aon_tl
          index: -1
        }
        {
          name: tl_sram_ctrl_ret_aon__regs
          struct: tl
          package: tlul_pkg
          type: req_rsp
          act: req
          inst_name: aon
          width: 1
          default: ""
          domain: Aon
          top_signame: sram_ctrl_ret_aon_regs_tl
          index: -1
        }
        {
          name: tl_sram_ctrl_ret_aon__ram
          struct: tl
          package: tlul_pkg
          type: req_rsp
          act: req
          inst_name: aon
          width: 1
          default: ""
          domain: Aon
          top_signame: sram_ctrl_ret_aon_ram_tl
          index: -1
        }
      ]
    }
    {
      name: socmbx
      clock_srcs:
      {
        clk_main_i: main
      }
      clock_group: secure
      reset: rst_main_ni
      reset_connections:
      {
        rst_main_ni:
        {
          name: lc_main
          domain: Main
        }
      }
      clock_connections:
      {
        clk_main_i: clk_main_i
      }
      domain: Main
      connections:
      {
        ahb_bridge.socmbx:
        [
          mbx0.soc
          mbx1.soc
        ]
      }
      nodes:
      [
        {
          name: ahb_bridge.socmbx
          type: host
          addr_space: soc_mbx
          clock: clk_main_i
          reset: rst_main_ni
          pipeline: false
          xbar: false
          stub: false
          inst_type: ""
          req_fifo_pass: true
          rsp_fifo_pass: true
        }
        {
          name: mbx0.soc
          type: device
          clock: clk_main_i
          reset: rst_main_ni
          pipeline: false
          inst_type: mbx
          addr_range:
          [
            {
              base_addrs:
              {
                soc_mbx: 0x0
              }
              size_byte: 0x20
            }
          ]
          xbar: false
          stub: false
          req_fifo_pass: true
        }
        {
          name: mbx1.soc
          type: device
          clock: clk_main_i
          reset: rst_main_ni
          pipeline: false
          inst_type: mbx
          addr_range:
          [
            {
              base_addrs:
              {
                soc_mbx: 0x100
              }
              size_byte: 0x20
            }
          ]
          xbar: false
          stub: false
          req_fifo_pass: true
        }
      ]
      addr_spaces:
      [
        soc_mbx
      ]
      clock: clk_main_i
      type: xbar
      inter_signal_list:
      [
        {
          name: tl_ahb_bridge__socmbx
          struct: tl
          package: tlul_pkg
          type: req_rsp
          act: rsp
          inst_name: socmbx
          width: 1
          default: ""
          end_idx: -1
          top_type: one-to-one
          top_signame: socmbx_tl_ahb_bridge__socmbx
          index: -1
        }
        {
          name: tl_mbx0__soc
          struct: tl
          package: tlul_pkg
          type: req_rsp
          act: req
          inst_name: socmbx
          width: 1
          default: ""
          domain: Main
          top_signame: mbx0_soc_tl_d
          index: -1
        }
        {
          name: tl_mbx1__soc
          struct: tl
          package: tlul_pkg
          type: req_rsp
          act: req
          inst_name: socmbx
          width: 1
          default: ""
          domain: Main
          top_signame: mbx1_soc_tl_d
          index: -1
        }
      ]
    }
    {
      name: socdbg
      clock_srcs:
      {
        clk_main_i: main
      }
      clock_group: secure
      reset: rst_main_ni
      reset_connections:
      {
        rst_main_ni:
        {
          name: lc_main
          domain: Main
        }
      }
      clock_connections:
      {
        clk_main_i: clk_main_i
      }
      domain: Main
      connections:
      {
        ext_socdbg_host:
        [
          lc_ctrl.dmi
          rv_dm.dbg
        ]
      }
      nodes:
      [
        {
          name: ext_socdbg_host
          type: host
          addr_space: soc_dbg
          clock: clk_main_i
          reset: rst_main_ni
          pipeline: false
          xbar: false
          stub: false
          inst_type: ""
          req_fifo_pass: true
          rsp_fifo_pass: true
        }
        {
          name: lc_ctrl.dmi
          type: device
          clock: clk_main_i
          reset: rst_main_ni
          pipeline: false
          inst_type: lc_ctrl
          addr_range:
          [
            {
              base_addrs:
              {
                soc_dbg: 0x3000
              }
              size_byte: 0x1000
            }
          ]
          xbar: false
          stub: false
          req_fifo_pass: true
        }
        {
          name: rv_dm.dbg
          type: device
          clock: clk_main_i
          reset: rst_main_ni
          pipeline: false
          inst_type: rv_dm
          addr_range:
          [
            {
              base_addrs:
              {
                soc_dbg: 0x0
              }
              size_byte: 0x200
            }
          ]
          xbar: false
          stub: false
          req_fifo_pass: true
        }
      ]
      addr_spaces:
      [
        soc_dbg
      ]
      clock: clk_main_i
      type: xbar
      inter_signal_list:
      [
        {
          name: tl_ext_socdbg_host
          struct: tl
          package: tlul_pkg
          type: req_rsp
          act: rsp
          inst_name: socdbg
          width: 1
          default: ""
          external: true
          conn_type: false
          index: -1
          top_signame: soc_dbg_tl
        }
        {
          name: tl_lc_ctrl__dmi
          struct: tl
          package: tlul_pkg
          type: req_rsp
          act: req
          inst_name: socdbg
          width: 1
          default: ""
          domain: Main
          top_signame: lc_ctrl_dmi_tl
          index: -1
        }
        {
          name: tl_rv_dm__dbg
          struct: tl
          package: tlul_pkg
          type: req_rsp
          act: req
          inst_name: socdbg
          width: 1
          default: ""
          domain: Main
          top_signame: rv_dm_dbg_tl_d
          index: -1
        }
      ]
    }
  ]
  pinout:
  {
    banks:
    [
      VCC
    ]
    pads:
    [
      {
        name: POR_N
        type: InputStd
        bank: VCC
        connection: manual
        desc: System reset
        port_type: inout
      }
    ]
  }
  pinmux:
  {
    signals: []
    enable_usb_wakeup: false
    enable_strap_sampling: false
  }
  targets:
  [
    {
      name: verilator
      chiplevel:
      {
        port_overrides:
        {
          ahb_bridge.ahb_mgr_m2s:
          {
            feedthrough: true
          }
          ahb_bridge.ahb_mgr_s2m:
          {
            feedthrough: true
          }
          ahb_bridge.ahb_sub_m2s:
          {
            feedthrough: true
          }
          ahb_bridge.ahb_sub_s2m:
          {
            feedthrough: true
          }
        }
      }
      pinout:
      {
        remove_ports: []
        remove_pads: []
        add_pads: []
      }
      pinmux:
      {
        special_signals: []
      }
    }
  ]
  incoming_alert:
  {
    soc:
    [
      {
        name: soc_fatal_alert_0
        module_name: soc
        index: 0
        type: alert
        async: 1
        width: 1
        lpg_idx: 0
      }
      {
        name: soc_fatal_alert_1
        module_name: soc
        index: 1
        type: alert
        async: 1
        width: 1
        lpg_idx: 0
      }
      {
        name: soc_fatal_alert_2
        module_name: soc
        index: 2
        type: alert
        async: 1
        width: 1
        lpg_idx: 0
      }
      {
        name: soc_fatal_alert_3
        module_name: soc
        index: 3
        type: alert
        async: 1
        width: 1
        lpg_idx: 0
      }
    ]
  }
  incoming_interrupt:
  {
    soc:
    [
      {
        name: irq_0
        module_name: soc
        domain: Main
        intr_type: Status
        default_val: "false"
      }
      {
        name: irq_1
        module_name: soc
        domain: Main
        intr_type: Status
        default_val: "false"
      }
      {
        name: irq_2
        module_name: soc
        domain: Main
        intr_type: Status
        default_val: "false"
      }
      {
        name: irq_3
        module_name: soc
        domain: Main
        intr_type: Status
        default_val: "false"
      }
    ]
  }
  exported_clks: {}
  wakeups:
  [
    {
      name: wkup_req
      width: "1"
      module: soc
    }
  ]
  unmanaged_resets: {}
  exported_rsts: {}
  alert:
  [
    {
      name: pwrmgr_fatal_fault
      width: 1
      type: alert
      async: "1"
      handler: alert_handler
      module_name: pwrmgr
      desc: pwrmgr fatal_fault alert
      lpg_name: ext_por_aon_Aon
      lpg_idx: 0
    }
    {
      name: rstmgr_fatal_fault
      width: 1
      type: alert
      async: "1"
      handler: alert_handler
      module_name: rstmgr
      desc: rstmgr fatal_fault alert
      lpg_name: ext_lc_aon_Aon
      lpg_idx: 1
    }
    {
      name: rstmgr_fatal_cnsty_fault
      width: 1
      type: alert
      async: "1"
      handler: alert_handler
      module_name: rstmgr
      desc: rstmgr fatal_cnsty_fault alert
      lpg_name: ext_lc_aon_Aon
      lpg_idx: 1
    }
    {
      name: clkmgr_recov_fault
      width: 1
      type: alert
      async: "1"
      handler: alert_handler
      module_name: clkmgr
      desc: clkmgr recov_fault alert
      lpg_name: ext_lc_aon_Aon
      lpg_idx: 1
    }
    {
      name: clkmgr_fatal_fault
      width: 1
      type: alert
      async: "1"
      handler: alert_handler
      module_name: clkmgr
      desc: clkmgr fatal_fault alert
      lpg_name: ext_lc_aon_Aon
      lpg_idx: 1
    }
    {
      name: rv_timer_aon_fatal_fault
      width: 1
      type: alert
      async: "1"
      handler: alert_handler
      module_name: rv_timer_aon
      desc: rv_timer_aon fatal_fault alert
      lpg_name: ext_lc_aon_Aon
      lpg_idx: 1
    }
    {
      name: sram_ctrl_ret_aon_fatal_error
      width: 1
      type: alert
      async: "1"
      handler: alert_handler
      module_name: sram_ctrl_ret_aon
      desc: sram_ctrl_ret_aon fatal_error alert
      lpg_name: ext_lc_aon_Aon
      lpg_idx: 1
    }
    {
      name: otp_ctrl_fatal_macro_error
      width: 1
      type: alert
      async: "1"
      handler: alert_handler
      module_name: otp_ctrl
      desc: otp_ctrl fatal_macro_error alert
      lpg_name: secure_lc_main_Main
      lpg_idx: 2
    }
    {
      name: otp_ctrl_fatal_check_error
      width: 1
      type: alert
      async: "1"
      handler: alert_handler
      module_name: otp_ctrl
      desc: otp_ctrl fatal_check_error alert
      lpg_name: secure_lc_main_Main
      lpg_idx: 2
    }
    {
      name: otp_ctrl_fatal_bus_integ_error
      width: 1
      type: alert
      async: "1"
      handler: alert_handler
      module_name: otp_ctrl
      desc: otp_ctrl fatal_bus_integ_error alert
      lpg_name: secure_lc_main_Main
      lpg_idx: 2
    }
    {
      name: otp_ctrl_fatal_prim_otp_alert
      width: 1
      type: alert
      async: "1"
      handler: alert_handler
      module_name: otp_ctrl
      desc: otp_ctrl fatal_prim_otp_alert alert
      lpg_name: secure_lc_main_Main
      lpg_idx: 2
    }
    {
      name: otp_ctrl_recov_prim_otp_alert
      width: 1
      type: alert
      async: "1"
      handler: alert_handler
      module_name: otp_ctrl
      desc: otp_ctrl recov_prim_otp_alert alert
      lpg_name: secure_lc_main_Main
      lpg_idx: 2
    }
    {
      name: lc_ctrl_fatal_prog_error
      width: 1
      type: alert
      async: "1"
      handler: alert_handler
      module_name: lc_ctrl
      desc: lc_ctrl fatal_prog_error alert
      lpg_name: secure_lc_main_Main
      lpg_idx: 2
    }
    {
      name: lc_ctrl_fatal_state_error
      width: 1
      type: alert
      async: "1"
      handler: alert_handler
      module_name: lc_ctrl
      desc: lc_ctrl fatal_state_error alert
      lpg_name: secure_lc_main_Main
      lpg_idx: 2
    }
    {
      name: lc_ctrl_fatal_bus_integ_error
      width: 1
      type: alert
      async: "1"
      handler: alert_handler
      module_name: lc_ctrl
      desc: lc_ctrl fatal_bus_integ_error alert
      lpg_name: secure_lc_main_Main
      lpg_idx: 2
    }
    {
      name: rv_dm_fatal_fault
      width: 1
      type: alert
      async: "1"
      handler: alert_handler
      module_name: rv_dm
      desc: rv_dm fatal_fault alert
      lpg_name: secure_sys_Main
      lpg_idx: 3
    }
    {
      name: rv_plic_fatal_fault
      width: 1
      type: alert
      async: "1"
      handler: alert_handler
      module_name: rv_plic
      desc: rv_plic fatal_fault alert
      lpg_name: secure_lc_main_Main
      lpg_idx: 2
    }
    {
      name: rv_timer_fatal_fault
      width: 1
      type: alert
      async: "1"
      handler: alert_handler
      module_name: rv_timer
      desc: rv_timer fatal_fault alert
      lpg_name: secure_lc_main_Main
      lpg_idx: 2
    }
    {
      name: aes_recov_ctrl_update_err
      width: 1
      type: alert
      async: "1"
      handler: alert_handler
      module_name: aes
      desc: aes recov_ctrl_update_err alert
      lpg_name: secure_lc_main_Main
      lpg_idx: 2
    }
    {
      name: aes_fatal_fault
      width: 1
      type: alert
      async: "1"
      handler: alert_handler
      module_name: aes
      desc: aes fatal_fault alert
      lpg_name: secure_lc_main_Main
      lpg_idx: 2
    }
    {
      name: hmac_fatal_fault
      width: 1
      type: alert
      async: "1"
      handler: alert_handler
      module_name: hmac
      desc: hmac fatal_fault alert
      lpg_name: secure_lc_main_Main
      lpg_idx: 2
    }
    {
      name: kmac_recov_operation_err
      width: 1
      type: alert
      async: "1"
      handler: alert_handler
      module_name: kmac
      desc: kmac recov_operation_err alert
      lpg_name: secure_lc_main_Main
      lpg_idx: 2
    }
    {
      name: kmac_fatal_fault_err
      width: 1
      type: alert
      async: "1"
      handler: alert_handler
      module_name: kmac
      desc: kmac fatal_fault_err alert
      lpg_name: secure_lc_main_Main
      lpg_idx: 2
    }
    {
      name: otbn_fatal
      width: 1
      type: alert
      async: "1"
      handler: alert_handler
      module_name: otbn
      desc: otbn fatal alert
      lpg_name: secure_lc_main_Main
      lpg_idx: 2
    }
    {
      name: otbn_recov
      width: 1
      type: alert
      async: "1"
      handler: alert_handler
      module_name: otbn
      desc: otbn recov alert
      lpg_name: secure_lc_main_Main
      lpg_idx: 2
    }
    {
      name: keymgr_dpe_recov_operation_err
      width: 1
      type: alert
      async: "1"
      handler: alert_handler
      module_name: keymgr_dpe
      desc: keymgr_dpe recov_operation_err alert
      lpg_name: secure_lc_main_Main
      lpg_idx: 2
    }
    {
      name: keymgr_dpe_fatal_fault_err
      width: 1
      type: alert
      async: "1"
      handler: alert_handler
      module_name: keymgr_dpe
      desc: keymgr_dpe fatal_fault_err alert
      lpg_name: secure_lc_main_Main
      lpg_idx: 2
    }
    {
      name: csrng_recov_alert
      width: 1
      type: alert
      async: "1"
      handler: alert_handler
      module_name: csrng
      desc: csrng recov_alert alert
      lpg_name: secure_lc_main_Main
      lpg_idx: 2
    }
    {
      name: csrng_fatal_alert
      width: 1
      type: alert
      async: "1"
      handler: alert_handler
      module_name: csrng
      desc: csrng fatal_alert alert
      lpg_name: secure_lc_main_Main
      lpg_idx: 2
    }
    {
      name: entropy_src_recov_alert
      width: 1
      type: alert
      async: "1"
      handler: alert_handler
      module_name: entropy_src
      desc: entropy_src recov_alert alert
      lpg_name: secure_lc_main_Main
      lpg_idx: 2
    }
    {
      name: entropy_src_fatal_alert
      width: 1
      type: alert
      async: "1"
      handler: alert_handler
      module_name: entropy_src
      desc: entropy_src fatal_alert alert
      lpg_name: secure_lc_main_Main
      lpg_idx: 2
    }
    {
      name: edn0_recov_alert
      width: 1
      type: alert
      async: "1"
      handler: alert_handler
      module_name: edn0
      desc: edn0 recov_alert alert
      lpg_name: secure_lc_main_Main
      lpg_idx: 2
    }
    {
      name: edn0_fatal_alert
      width: 1
      type: alert
      async: "1"
      handler: alert_handler
      module_name: edn0
      desc: edn0 fatal_alert alert
      lpg_name: secure_lc_main_Main
      lpg_idx: 2
    }
    {
      name: edn1_recov_alert
      width: 1
      type: alert
      async: "1"
      handler: alert_handler
      module_name: edn1
      desc: edn1 recov_alert alert
      lpg_name: secure_lc_main_Main
      lpg_idx: 2
    }
    {
      name: edn1_fatal_alert
      width: 1
      type: alert
      async: "1"
      handler: alert_handler
      module_name: edn1
      desc: edn1 fatal_alert alert
      lpg_name: secure_lc_main_Main
      lpg_idx: 2
    }
    {
      name: sram_ctrl_main_fatal_error
      width: 1
      type: alert
      async: "1"
      handler: alert_handler
      module_name: sram_ctrl_main
      desc: sram_ctrl_main fatal_error alert
      lpg_name: secure_lc_main_Main
      lpg_idx: 2
    }
    {
      name: rom_ctrl_fatal
      width: 1
      type: alert
      async: "1"
      handler: alert_handler
      module_name: rom_ctrl
      desc: rom_ctrl fatal alert
      lpg_name: secure_lc_main_Main
      lpg_idx: 2
    }
    {
      name: dma_fatal_fault
      width: 1
      type: alert
      async: "1"
      handler: alert_handler
      module_name: dma
      desc: dma fatal_fault alert
      lpg_name: secure_lc_main_Main
      lpg_idx: 2
    }
    {
      name: mbx0_fatal_fault
      width: 1
      type: alert
      async: "1"
      handler: alert_handler
      module_name: mbx0
      desc: mbx0 fatal_fault alert
      lpg_name: secure_lc_main_Main
      lpg_idx: 2
    }
    {
      name: mbx0_recov_fault
      width: 1
      type: alert
      async: "1"
      handler: alert_handler
      module_name: mbx0
      desc: mbx0 recov_fault alert
      lpg_name: secure_lc_main_Main
      lpg_idx: 2
    }
    {
      name: mbx1_fatal_fault
      width: 1
      type: alert
      async: "1"
      handler: alert_handler
      module_name: mbx1
      desc: mbx1 fatal_fault alert
      lpg_name: secure_lc_main_Main
      lpg_idx: 2
    }
    {
      name: mbx1_recov_fault
      width: 1
      type: alert
      async: "1"
      handler: alert_handler
      module_name: mbx1
      desc: mbx1 recov_fault alert
      lpg_name: secure_lc_main_Main
      lpg_idx: 2
    }
    {
      name: rv_core_ibex_fatal_sw_err
      width: 1
      type: alert
      async: "1"
      handler: alert_handler
      module_name: rv_core_ibex
      desc: rv_core_ibex fatal_sw_err alert
      lpg_name: secure_lc_main_Main
      lpg_idx: 2
    }
    {
      name: rv_core_ibex_recov_sw_err
      width: 1
      type: alert
      async: "1"
      handler: alert_handler
      module_name: rv_core_ibex
      desc: rv_core_ibex recov_sw_err alert
      lpg_name: secure_lc_main_Main
      lpg_idx: 2
    }
    {
      name: rv_core_ibex_fatal_hw_err
      width: 1
      type: alert
      async: "1"
      handler: alert_handler
      module_name: rv_core_ibex
      desc: rv_core_ibex fatal_hw_err alert
      lpg_name: secure_lc_main_Main
      lpg_idx: 2
    }
    {
      name: rv_core_ibex_recov_hw_err
      width: 1
      type: alert
      async: "1"
      handler: alert_handler
      module_name: rv_core_ibex
      desc: rv_core_ibex recov_hw_err alert
      lpg_name: secure_lc_main_Main
      lpg_idx: 2
    }
  ]
  outgoing_alert: {}
  interrupt:
  [
    {
      name: pwrmgr_wakeup
      width: 1
      type: interrupt
      module_name: pwrmgr
      desc: pwrmgr wakeup interrupt
      intr_type: IntrType.Event
      default_val: false
      incoming: false
      domain: Aon
      plic: rv_plic
      outgoing: false
    }
    {
      name: alert_handler_classa
      width: 1
      type: interrupt
      module_name: alert_handler
      desc: alert_handler classa interrupt
      intr_type: IntrType.Event
      default_val: false
      incoming: false
      domain: Aon
      plic: rv_plic
      outgoing: false
    }
    {
      name: alert_handler_classb
      width: 1
      type: interrupt
      module_name: alert_handler
      desc: alert_handler classb interrupt
      intr_type: IntrType.Event
      default_val: false
      incoming: false
      domain: Aon
      plic: rv_plic
      outgoing: false
    }
    {
      name: alert_handler_classc
      width: 1
      type: interrupt
      module_name: alert_handler
      desc: alert_handler classc interrupt
      intr_type: IntrType.Event
      default_val: false
      incoming: false
      domain: Aon
      plic: rv_plic
      outgoing: false
    }
    {
      name: alert_handler_classd
      width: 1
      type: interrupt
      module_name: alert_handler
      desc: alert_handler classd interrupt
      intr_type: IntrType.Event
      default_val: false
      incoming: false
      domain: Aon
      plic: rv_plic
      outgoing: false
    }
    {
      name: rv_timer_aon_timer_expired_hart0_timer0
      width: 1
      type: interrupt
      module_name: rv_timer_aon
      desc: rv_timer_aon timer_expired_hart0_timer0 interrupt
      intr_type: IntrType.Event
      default_val: false
      incoming: false
      domain: Aon
      plic: rv_plic
      outgoing: false
    }
    {
      name: otp_ctrl_otp_operation_done
      width: 1
      type: interrupt
      module_name: otp_ctrl
      desc: otp_ctrl otp_operation_done interrupt
      intr_type: IntrType.Event
      default_val: false
      incoming: false
      domain: Main
      plic: rv_plic
      outgoing: false
    }
    {
      name: otp_ctrl_otp_error
      width: 1
      type: interrupt
      module_name: otp_ctrl
      desc: otp_ctrl otp_error interrupt
      intr_type: IntrType.Event
      default_val: false
      incoming: false
      domain: Main
      plic: rv_plic
      outgoing: false
    }
    {
      name: rv_timer_timer_expired_hart0_timer0
      width: 1
      type: interrupt
      module_name: rv_timer
      desc: rv_timer timer_expired_hart0_timer0 interrupt
      intr_type: IntrType.Event
      default_val: false
      incoming: false
      domain: Main
      plic: rv_plic
      outgoing: false
    }
    {
      name: hmac_hmac_done
      width: 1
      type: interrupt
      module_name: hmac
      desc: hmac hmac_done interrupt
      intr_type: IntrType.Event
      default_val: false
      incoming: false
      domain: Main
      plic: rv_plic
      outgoing: false
    }
    {
      name: hmac_fifo_empty
      width: 1
      type: interrupt
      module_name: hmac
      desc: hmac fifo_empty interrupt
      intr_type: IntrType.Status
      default_val: false
      incoming: false
      domain: Main
      plic: rv_plic
      outgoing: false
    }
    {
      name: hmac_hmac_err
      width: 1
      type: interrupt
      module_name: hmac
      desc: hmac hmac_err interrupt
      intr_type: IntrType.Event
      default_val: false
      incoming: false
      domain: Main
      plic: rv_plic
      outgoing: false
    }
    {
      name: kmac_kmac_done
      width: 1
      type: interrupt
      module_name: kmac
      desc: kmac kmac_done interrupt
      intr_type: IntrType.Event
      default_val: false
      incoming: false
      domain: Main
      plic: rv_plic
      outgoing: false
    }
    {
      name: kmac_fifo_empty
      width: 1
      type: interrupt
      module_name: kmac
      desc: kmac fifo_empty interrupt
      intr_type: IntrType.Status
      default_val: false
      incoming: false
      domain: Main
      plic: rv_plic
      outgoing: false
    }
    {
      name: kmac_kmac_err
      width: 1
      type: interrupt
      module_name: kmac
      desc: kmac kmac_err interrupt
      intr_type: IntrType.Event
      default_val: false
      incoming: false
      domain: Main
      plic: rv_plic
      outgoing: false
    }
    {
      name: otbn_done
      width: 1
      type: interrupt
      module_name: otbn
      desc: otbn done interrupt
      intr_type: IntrType.Event
      default_val: false
      incoming: false
      domain: Main
      plic: rv_plic
      outgoing: false
    }
    {
      name: keymgr_dpe_op_done
      width: 1
      type: interrupt
      module_name: keymgr_dpe
      desc: keymgr_dpe op_done interrupt
      intr_type: IntrType.Event
      default_val: false
      incoming: false
      domain: Main
      plic: rv_plic
      outgoing: false
    }
    {
      name: csrng_cs_cmd_req_done
      width: 1
      type: interrupt
      module_name: csrng
      desc: csrng cs_cmd_req_done interrupt
      intr_type: IntrType.Event
      default_val: false
      incoming: false
      domain: Main
      plic: rv_plic
      outgoing: false
    }
    {
      name: csrng_cs_entropy_req
      width: 1
      type: interrupt
      module_name: csrng
      desc: csrng cs_entropy_req interrupt
      intr_type: IntrType.Event
      default_val: false
      incoming: false
      domain: Main
      plic: rv_plic
      outgoing: false
    }
    {
      name: csrng_cs_hw_inst_exc
      width: 1
      type: interrupt
      module_name: csrng
      desc: csrng cs_hw_inst_exc interrupt
      intr_type: IntrType.Event
      default_val: false
      incoming: false
      domain: Main
      plic: rv_plic
      outgoing: false
    }
    {
      name: csrng_cs_fatal_err
      width: 1
      type: interrupt
      module_name: csrng
      desc: csrng cs_fatal_err interrupt
      intr_type: IntrType.Event
      default_val: false
      incoming: false
      domain: Main
      plic: rv_plic
      outgoing: false
    }
    {
      name: entropy_src_es_entropy_valid
      width: 1
      type: interrupt
      module_name: entropy_src
      desc: entropy_src es_entropy_valid interrupt
      intr_type: IntrType.Event
      default_val: false
      incoming: false
      domain: Main
      plic: rv_plic
      outgoing: false
    }
    {
      name: entropy_src_es_health_test_failed
      width: 1
      type: interrupt
      module_name: entropy_src
      desc: entropy_src es_health_test_failed interrupt
      intr_type: IntrType.Event
      default_val: false
      incoming: false
      domain: Main
      plic: rv_plic
      outgoing: false
    }
    {
      name: entropy_src_es_observe_fifo_ready
      width: 1
      type: interrupt
      module_name: entropy_src
      desc: entropy_src es_observe_fifo_ready interrupt
      intr_type: IntrType.Event
      default_val: false
      incoming: false
      domain: Main
      plic: rv_plic
      outgoing: false
    }
    {
      name: entropy_src_es_fatal_err
      width: 1
      type: interrupt
      module_name: entropy_src
      desc: entropy_src es_fatal_err interrupt
      intr_type: IntrType.Event
      default_val: false
      incoming: false
      domain: Main
      plic: rv_plic
      outgoing: false
    }
    {
      name: edn0_edn_cmd_req_done
      width: 1
      type: interrupt
      module_name: edn0
      desc: edn0 edn_cmd_req_done interrupt
      intr_type: IntrType.Event
      default_val: false
      incoming: false
      domain: Main
      plic: rv_plic
      outgoing: false
    }
    {
      name: edn0_edn_fatal_err
      width: 1
      type: interrupt
      module_name: edn0
      desc: edn0 edn_fatal_err interrupt
      intr_type: IntrType.Event
      default_val: false
      incoming: false
      domain: Main
      plic: rv_plic
      outgoing: false
    }
    {
      name: edn1_edn_cmd_req_done
      width: 1
      type: interrupt
      module_name: edn1
      desc: edn1 edn_cmd_req_done interrupt
      intr_type: IntrType.Event
      default_val: false
      incoming: false
      domain: Main
      plic: rv_plic
      outgoing: false
    }
    {
      name: edn1_edn_fatal_err
      width: 1
      type: interrupt
      module_name: edn1
      desc: edn1 edn_fatal_err interrupt
      intr_type: IntrType.Event
      default_val: false
      incoming: false
      domain: Main
      plic: rv_plic
      outgoing: false
    }
    {
      name: dma_dma_done
      width: 1
      type: interrupt
      module_name: dma
      desc: dma dma_done interrupt
      intr_type: IntrType.Status
      default_val: false
      incoming: false
      domain: Main
      plic: rv_plic
      outgoing: false
    }
    {
      name: dma_dma_chunk_done
      width: 1
      type: interrupt
      module_name: dma
      desc: dma dma_chunk_done interrupt
      intr_type: IntrType.Status
      default_val: false
      incoming: false
      domain: Main
      plic: rv_plic
      outgoing: false
    }
    {
      name: dma_dma_error
      width: 1
      type: interrupt
      module_name: dma
      desc: dma dma_error interrupt
      intr_type: IntrType.Status
      default_val: false
      incoming: false
      domain: Main
      plic: rv_plic
      outgoing: false
    }
    {
      name: mbx0_mbx_ready
      width: 1
      type: interrupt
      module_name: mbx0
      desc: mbx0 mbx_ready interrupt
      intr_type: IntrType.Event
      default_val: false
      incoming: false
      domain: Main
      plic: rv_plic
      outgoing: false
    }
    {
      name: mbx0_mbx_abort
      width: 1
      type: interrupt
      module_name: mbx0
      desc: mbx0 mbx_abort interrupt
      intr_type: IntrType.Event
      default_val: false
      incoming: false
      domain: Main
      plic: rv_plic
      outgoing: false
    }
    {
      name: mbx0_mbx_error
      width: 1
      type: interrupt
      module_name: mbx0
      desc: mbx0 mbx_error interrupt
      intr_type: IntrType.Event
      default_val: false
      incoming: false
      domain: Main
      plic: rv_plic
      outgoing: false
    }
    {
      name: mbx1_mbx_ready
      width: 1
      type: interrupt
      module_name: mbx1
      desc: mbx1 mbx_ready interrupt
      intr_type: IntrType.Event
      default_val: false
      incoming: false
      domain: Main
      plic: rv_plic
      outgoing: false
    }
    {
      name: mbx1_mbx_abort
      width: 1
      type: interrupt
      module_name: mbx1
      desc: mbx1 mbx_abort interrupt
      intr_type: IntrType.Event
      default_val: false
      incoming: false
      domain: Main
      plic: rv_plic
      outgoing: false
    }
    {
      name: mbx1_mbx_error
      width: 1
      type: interrupt
      module_name: mbx1
      desc: mbx1 mbx_error interrupt
      intr_type: IntrType.Event
      default_val: false
      incoming: false
      domain: Main
      plic: rv_plic
      outgoing: false
    }
    {
      name: soc_irq_0
      module_name: soc
      domain: Main
      intr_type: Status
      default_val: "false"
      desc: soc irq_0 incoming interrupt
      incoming: true
      width: 1
      plic: rv_plic
      outgoing: false
    }
    {
      name: soc_irq_1
      module_name: soc
      domain: Main
      intr_type: Status
      default_val: "false"
      desc: soc irq_1 incoming interrupt
      incoming: true
      width: 1
      plic: rv_plic
      outgoing: false
    }
    {
      name: soc_irq_2
      module_name: soc
      domain: Main
      intr_type: Status
      default_val: "false"
      desc: soc irq_2 incoming interrupt
      incoming: true
      width: 1
      plic: rv_plic
      outgoing: false
    }
    {
      name: soc_irq_3
      module_name: soc
      domain: Main
      intr_type: Status
      default_val: "false"
      desc: soc irq_3 incoming interrupt
      incoming: true
      width: 1
      plic: rv_plic
      outgoing: false
    }
  ]
  outgoing_interrupt: {}
  plic_info:
  {
    rv_plic:
    {
      domain: Main
      count_tot: 43
      count_pd:
      {
        Aon: 6
        Main: 36
      }
    }
  }
  inter_pd:
  {
    definitions:
    [
      {
        package: ""
        struct: logic
        domain: chip
        signame: intr_vector_pd_aon
        width: 6
        type: uni
        special: interrupt
        end_idx: -1
        act: req
        suffix: ""
        default: "'0"
      }
      {
        package: prim_alert_pkg
        struct: alert_tx
        domain: chip
        signame: alert_tx_pd_main
        width: 39
        type: uni
        special: alert
        end_idx: -1
        act: req
        suffix: ""
        default: "'0"
      }
      {
        package: prim_alert_pkg
        struct: alert_rx
        domain: chip
        signame: alert_rx_pd_main
        width: 39
        type: uni
        special: alert
        end_idx: -1
        act: req
        suffix: ""
        default: "'0"
      }
      {
        package: ""
        struct: logic
        domain: chip
        signame: clk_aon
        width: 1
        type: uni
        end_idx: -1
        default: "'0"
      }
      {
        package: ""
        struct: logic
        domain: chip
        signame: clk_main
        width: 1
        type: uni
        end_idx: -1
        default: "'0"
      }
      {
        package: ""
        struct: logic
        domain: chip
        signame: rst_main_aon_n
        width: 1
        type: uni
        end_idx: -1
        default: "'0"
      }
      {
        package: ""
        struct: logic
        domain: chip
        signame: rst_main_n
        width: 1
        type: uni
        end_idx: -1
        default: "'0"
      }
      {
        package: ""
        struct: logic
        domain: chip
        signame: rst_main_shadowed_n
        width: 1
        type: uni
        end_idx: -1
        default: "'0"
      }
      {
        package: ""
        struct: logic
        domain: chip
        signame: rst_main_sys_n
        width: 1
        type: uni
        end_idx: -1
        default: "'0"
      }
      {
        package: pwrmgr_pkg
        struct: pwr_otp_req
        domain: chip
        signame: pwrmgr_pwr_otp_req
        width: 1
        type: req_rsp
        end_idx: -1
        act: req
        suffix: req
        default: pwrmgr_pkg::PWR_OTP_REQ_DEFAULT
      }
      {
        package: pwrmgr_pkg
        struct: pwr_otp_rsp
        domain: chip
        signame: pwrmgr_pwr_otp_rsp
        width: 1
        type: req_rsp
        end_idx: -1
        act: req
        suffix: rsp
        default: pwrmgr_pkg::PWR_OTP_RSP_DEFAULT
      }
      {
        package: lc_ctrl_pkg
        struct: pwr_lc_req
        domain: chip
        signame: pwrmgr_pwr_lc_req
        width: 1
        type: req_rsp
        end_idx: -1
        act: req
        suffix: req
        default: lc_ctrl_pkg::PWR_LC_REQ_DEFAULT
      }
      {
        package: lc_ctrl_pkg
        struct: pwr_lc_rsp
        domain: chip
        signame: pwrmgr_pwr_lc_rsp
        width: 1
        type: req_rsp
        end_idx: -1
        act: req
        suffix: rsp
        default: lc_ctrl_pkg::PWR_LC_RSP_DEFAULT
      }
      {
        package: ""
        struct: logic
        domain: chip
        signame: pwrmgr_strap
        width: 1
        type: uni
        end_idx: -1
        act: req
        suffix: ""
        default: 1'b0
      }
      {
        package: lc_ctrl_pkg
        struct: lc_tx
        domain: chip
        signame: pwrmgr_fetch_en
        width: 1
        type: uni
        end_idx: -1
        act: req
        suffix: ""
        default: lc_ctrl_pkg::LC_TX_DEFAULT
      }
      {
        package: rom_ctrl_pkg
        struct: pwrmgr_data
        domain: chip
        signame: pwrmgr_rom_ctrl
        width: 1
        type: uni
        end_idx: -1
        act: rcv
        suffix: ""
        default: rom_ctrl_pkg::PWRMGR_DATA_DEFAULT
      }
      {
        package: prim_esc_pkg
        struct: esc_rx
        domain: chip
        signame: alert_handler_esc_rx
        width: 3
        type: uni
        end_idx: -1
        act: rcv
        suffix: ""
        default: "'{default: prim_esc_pkg::ESC_RX_DEFAULT}"
      }
      {
        package: prim_esc_pkg
        struct: esc_tx
        domain: chip
        signame: alert_handler_esc_tx
        width: 3
        type: uni
        end_idx: -1
        act: req
        suffix: ""
        default: "'{default: prim_esc_pkg::ESC_TX_DEFAULT}"
      }
      {
        package: edn_pkg
        struct: edn_req
        domain: chip
        signame: edn0_edn_req
        width: 1
        type: req_rsp
        end_idx: 7
        act: rsp
        suffix: req
        default: "'0"
      }
      {
        package: edn_pkg
        struct: edn_rsp
        domain: chip
        signame: edn0_edn_rsp
        width: 1
        type: req_rsp
        end_idx: 7
        act: rsp
        suffix: rsp
        default: "'0"
      }
      {
        package: otp_ctrl_pkg
        struct: sram_otp_key_req
        domain: chip
        signame: otp_ctrl_sram_otp_key_req
        width: 1
        type: req_rsp
        end_idx: 3
        act: rsp
        suffix: req
        default: "'0"
      }
      {
        package: otp_ctrl_pkg
        struct: sram_otp_key_rsp
        domain: chip
        signame: otp_ctrl_sram_otp_key_rsp
        width: 1
        type: req_rsp
        end_idx: 3
        act: rsp
        suffix: rsp
        default: "'0"
      }
      {
        package: lc_ctrl_pkg
        struct: lc_tx
        domain: chip
        signame: lc_ctrl_lc_dft_en
        width: 1
        type: uni
        end_idx: -1
        act: req
        suffix: ""
        default: lc_ctrl_pkg::Off
      }
      {
        package: lc_ctrl_pkg
        struct: lc_tx
        domain: chip
        signame: lc_ctrl_lc_hw_debug_en
        width: 1
        type: uni
        end_idx: -1
        act: req
        suffix: ""
        default: lc_ctrl_pkg::Off
      }
      {
        package: lc_ctrl_pkg
        struct: lc_tx
        domain: chip
        signame: lc_ctrl_lc_escalate_en
        width: 1
        type: uni
        end_idx: -1
        act: req
        suffix: ""
        default: lc_ctrl_pkg::Off
      }
      {
        package: rv_core_ibex_pkg
        struct: cpu_crash_dump
        domain: chip
        signame: rv_core_ibex_crash_dump
        width: 1
        type: uni
        end_idx: -1
        act: req
        suffix: ""
        default: rv_core_ibex_pkg::CPU_CRASH_DUMP_DEFAULT
      }
      {
        package: rv_core_ibex_pkg
        struct: cpu_pwrmgr
        domain: chip
        signame: rv_core_ibex_pwrmgr
        width: 1
        type: uni
        end_idx: -1
        act: req
        suffix: ""
        default: rv_core_ibex_pkg::CPU_PWRMGR_DEFAULT
      }
      {
        package: ""
        struct: logic
        domain: chip
        signame: rv_dm_ndmreset_req
        width: 1
        type: uni
        end_idx: -1
        act: req
        suffix: ""
        default: 1'b0
      }
      {
        package: tlul_pkg
        struct: tl_h2d
        domain: chip
        signame: main_tl_aon_req
        width: 1
        type: req_rsp
        end_idx: -1
        act: req
        suffix: req
        default: tlul_pkg::TL_H2D_DEFAULT
      }
      {
        package: tlul_pkg
        struct: tl_d2h
        domain: chip
        signame: main_tl_aon_rsp
        width: 1
        type: req_rsp
        end_idx: -1
        act: req
        suffix: rsp
        default: tlul_pkg::TL_D2H_DEFAULT
      }
    ]
  }
  alert_module:
  [
    pwrmgr
    rstmgr
    clkmgr
    rv_timer_aon
    sram_ctrl_ret_aon
    otp_ctrl
    lc_ctrl
    rv_dm
    rv_plic
    rv_timer
    aes
    hmac
    kmac
    otbn
    keymgr_dpe
    csrng
    entropy_src
    edn0
    edn1
    sram_ctrl_main
    rom_ctrl
    dma
    mbx0
    mbx1
    rv_core_ibex
  ]
  alert_connections:
  {
    module_pwrmgr:
    {
      tx_expr: alert_tx[0]
      rx_expr: alert_rx[0]
      async_expr: alert_handler_reg_pkg::AsyncOn[0]
      comments:
      [
        alert_handler[0]: fatal_fault
      ]
    }
    module_rstmgr:
    {
      tx_expr: alert_tx[2:1]
      rx_expr: alert_rx[2:1]
      async_expr: alert_handler_reg_pkg::AsyncOn[2:1]
      comments:
      [
        alert_handler[1]: fatal_fault
        alert_handler[2]: fatal_cnsty_fault
      ]
    }
    module_clkmgr:
    {
      tx_expr: alert_tx[4:3]
      rx_expr: alert_rx[4:3]
      async_expr: alert_handler_reg_pkg::AsyncOn[4:3]
      comments:
      [
        alert_handler[3]: recov_fault
        alert_handler[4]: fatal_fault
      ]
    }
    module_rv_timer_aon:
    {
      tx_expr: alert_tx[5]
      rx_expr: alert_rx[5]
      async_expr: alert_handler_reg_pkg::AsyncOn[5]
      comments:
      [
        alert_handler[5]: fatal_fault
      ]
    }
    module_sram_ctrl_ret_aon:
    {
      tx_expr: alert_tx[6]
      rx_expr: alert_rx[6]
      async_expr: alert_handler_reg_pkg::AsyncOn[6]
      comments:
      [
        alert_handler[6]: fatal_error
      ]
    }
    module_otp_ctrl:
    {
      tx_expr: alert_tx_o[4:0]
      rx_expr: alert_rx_i[4:0]
      async_expr: alert_handler_reg_pkg::AsyncOn[11:7]
      comments:
      [
        alert_handler[7]: fatal_macro_error
        alert_handler[8]: fatal_check_error
        alert_handler[9]: fatal_bus_integ_error
        alert_handler[10]: fatal_prim_otp_alert
        alert_handler[11]: recov_prim_otp_alert
      ]
    }
    module_lc_ctrl:
    {
      tx_expr: alert_tx_o[7:5]
      rx_expr: alert_rx_i[7:5]
      async_expr: alert_handler_reg_pkg::AsyncOn[14:12]
      comments:
      [
        alert_handler[12]: fatal_prog_error
        alert_handler[13]: fatal_state_error
        alert_handler[14]: fatal_bus_integ_error
      ]
    }
    module_rv_dm:
    {
      tx_expr: alert_tx_o[8]
      rx_expr: alert_rx_i[8]
      async_expr: alert_handler_reg_pkg::AsyncOn[15]
      comments:
      [
        alert_handler[15]: fatal_fault
      ]
    }
    module_rv_plic:
    {
      tx_expr: alert_tx_o[9]
      rx_expr: alert_rx_i[9]
      async_expr: alert_handler_reg_pkg::AsyncOn[16]
      comments:
      [
        alert_handler[16]: fatal_fault
      ]
    }
    module_rv_timer:
    {
      tx_expr: alert_tx_o[10]
      rx_expr: alert_rx_i[10]
      async_expr: alert_handler_reg_pkg::AsyncOn[17]
      comments:
      [
        alert_handler[17]: fatal_fault
      ]
    }
    module_aes:
    {
      tx_expr: alert_tx_o[12:11]
      rx_expr: alert_rx_i[12:11]
      async_expr: alert_handler_reg_pkg::AsyncOn[19:18]
      comments:
      [
        alert_handler[18]: recov_ctrl_update_err
        alert_handler[19]: fatal_fault
      ]
    }
    module_hmac:
    {
      tx_expr: alert_tx_o[13]
      rx_expr: alert_rx_i[13]
      async_expr: alert_handler_reg_pkg::AsyncOn[20]
      comments:
      [
        alert_handler[20]: fatal_fault
      ]
    }
    module_kmac:
    {
      tx_expr: alert_tx_o[15:14]
      rx_expr: alert_rx_i[15:14]
      async_expr: alert_handler_reg_pkg::AsyncOn[22:21]
      comments:
      [
        alert_handler[21]: recov_operation_err
        alert_handler[22]: fatal_fault_err
      ]
    }
    module_otbn:
    {
      tx_expr: alert_tx_o[17:16]
      rx_expr: alert_rx_i[17:16]
      async_expr: alert_handler_reg_pkg::AsyncOn[24:23]
      comments:
      [
        alert_handler[23]: fatal
        alert_handler[24]: recov
      ]
    }
    module_keymgr_dpe:
    {
      tx_expr: alert_tx_o[19:18]
      rx_expr: alert_rx_i[19:18]
      async_expr: alert_handler_reg_pkg::AsyncOn[26:25]
      comments:
      [
        alert_handler[25]: recov_operation_err
        alert_handler[26]: fatal_fault_err
      ]
    }
    module_csrng:
    {
      tx_expr: alert_tx_o[21:20]
      rx_expr: alert_rx_i[21:20]
      async_expr: alert_handler_reg_pkg::AsyncOn[28:27]
      comments:
      [
        alert_handler[27]: recov_alert
        alert_handler[28]: fatal_alert
      ]
    }
    module_entropy_src:
    {
      tx_expr: alert_tx_o[23:22]
      rx_expr: alert_rx_i[23:22]
      async_expr: alert_handler_reg_pkg::AsyncOn[30:29]
      comments:
      [
        alert_handler[29]: recov_alert
        alert_handler[30]: fatal_alert
      ]
    }
    module_edn0:
    {
      tx_expr: alert_tx_o[25:24]
      rx_expr: alert_rx_i[25:24]
      async_expr: alert_handler_reg_pkg::AsyncOn[32:31]
      comments:
      [
        alert_handler[31]: recov_alert
        alert_handler[32]: fatal_alert
      ]
    }
    module_edn1:
    {
      tx_expr: alert_tx_o[27:26]
      rx_expr: alert_rx_i[27:26]
      async_expr: alert_handler_reg_pkg::AsyncOn[34:33]
      comments:
      [
        alert_handler[33]: recov_alert
        alert_handler[34]: fatal_alert
      ]
    }
    module_sram_ctrl_main:
    {
      tx_expr: alert_tx_o[28]
      rx_expr: alert_rx_i[28]
      async_expr: alert_handler_reg_pkg::AsyncOn[35]
      comments:
      [
        alert_handler[35]: fatal_error
      ]
    }
    module_rom_ctrl:
    {
      tx_expr: alert_tx_o[29]
      rx_expr: alert_rx_i[29]
      async_expr: alert_handler_reg_pkg::AsyncOn[36]
      comments:
      [
        alert_handler[36]: fatal
      ]
    }
    module_dma:
    {
      tx_expr: alert_tx_o[30]
      rx_expr: alert_rx_i[30]
      async_expr: alert_handler_reg_pkg::AsyncOn[37]
      comments:
      [
        alert_handler[37]: fatal_fault
      ]
    }
    module_mbx0:
    {
      tx_expr: alert_tx_o[32:31]
      rx_expr: alert_rx_i[32:31]
      async_expr: alert_handler_reg_pkg::AsyncOn[39:38]
      comments:
      [
        alert_handler[38]: fatal_fault
        alert_handler[39]: recov_fault
      ]
    }
    module_mbx1:
    {
      tx_expr: alert_tx_o[34:33]
      rx_expr: alert_rx_i[34:33]
      async_expr: alert_handler_reg_pkg::AsyncOn[41:40]
      comments:
      [
        alert_handler[40]: fatal_fault
        alert_handler[41]: recov_fault
      ]
    }
    module_rv_core_ibex:
    {
      tx_expr: alert_tx_o[38:35]
      rx_expr: alert_rx_i[38:35]
      async_expr: alert_handler_reg_pkg::AsyncOn[45:42]
      comments:
      [
        alert_handler[42]: fatal_sw_err
        alert_handler[43]: recov_sw_err
        alert_handler[44]: fatal_hw_err
        alert_handler[45]: recov_hw_err
      ]
    }
    incoming_soc:
    {
      tx_expr: alert_tx[49:46]
      rx_expr: alert_rx[49:46]
      async_expr: null
      comments:
      [
        alert_handler[46]: soc_fatal_alert_0
        alert_handler[47]: soc_fatal_alert_1
        alert_handler[48]: soc_fatal_alert_2
        alert_handler[49]: soc_fatal_alert_3
      ]
    }
  }
  alert_handler_info:
  {
    alert_handler:
    {
      domain: Aon
      count_tot: 46
      count_pd:
      {
        Aon: 7
        Main: 39
      }
      connect_pd:
      {
        7:
        {
          src_pd: Main
          idx: 0
        }
        8:
        {
          src_pd: Main
          idx: 1
        }
        9:
        {
          src_pd: Main
          idx: 2
        }
        10:
        {
          src_pd: Main
          idx: 3
        }
        11:
        {
          src_pd: Main
          idx: 4
        }
        12:
        {
          src_pd: Main
          idx: 5
        }
        13:
        {
          src_pd: Main
          idx: 6
        }
        14:
        {
          src_pd: Main
          idx: 7
        }
        15:
        {
          src_pd: Main
          idx: 8
        }
        16:
        {
          src_pd: Main
          idx: 9
        }
        17:
        {
          src_pd: Main
          idx: 10
        }
        18:
        {
          src_pd: Main
          idx: 11
        }
        19:
        {
          src_pd: Main
          idx: 12
        }
        20:
        {
          src_pd: Main
          idx: 13
        }
        21:
        {
          src_pd: Main
          idx: 14
        }
        22:
        {
          src_pd: Main
          idx: 15
        }
        23:
        {
          src_pd: Main
          idx: 16
        }
        24:
        {
          src_pd: Main
          idx: 17
        }
        25:
        {
          src_pd: Main
          idx: 18
        }
        26:
        {
          src_pd: Main
          idx: 19
        }
        27:
        {
          src_pd: Main
          idx: 20
        }
        28:
        {
          src_pd: Main
          idx: 21
        }
        29:
        {
          src_pd: Main
          idx: 22
        }
        30:
        {
          src_pd: Main
          idx: 23
        }
        31:
        {
          src_pd: Main
          idx: 24
        }
        32:
        {
          src_pd: Main
          idx: 25
        }
        33:
        {
          src_pd: Main
          idx: 26
        }
        34:
        {
          src_pd: Main
          idx: 27
        }
        35:
        {
          src_pd: Main
          idx: 28
        }
        36:
        {
          src_pd: Main
          idx: 29
        }
        37:
        {
          src_pd: Main
          idx: 30
        }
        38:
        {
          src_pd: Main
          idx: 31
        }
        39:
        {
          src_pd: Main
          idx: 32
        }
        40:
        {
          src_pd: Main
          idx: 33
        }
        41:
        {
          src_pd: Main
          idx: 34
        }
        42:
        {
          src_pd: Main
          idx: 35
        }
        43:
        {
          src_pd: Main
          idx: 36
        }
        44:
        {
          src_pd: Main
          idx: 37
        }
        45:
        {
          src_pd: Main
          idx: 38
        }
      }
    }
  }
  interrupt_module:
  [
    pwrmgr
    alert_handler
    rv_timer_aon
    otp_ctrl
    rv_timer
    hmac
    kmac
    otbn
    keymgr_dpe
    csrng
    entropy_src
    edn0
    edn1
    dma
    mbx0
    mbx1
  ]
  outgoing_alert_module: {}
  outgoing_interrupt_module: {}
  alert_lpgs:
  [
    {
      name: ext_por_aon_Aon
      clock_group:
      {
        name: ext
        src: ext
        sw_cg: no
        unique: no
        clocks:
        {
          clk_aon_i: aon
          clk_main_i: main
        }
      }
      clock_connection: clk_aon_i
      unmanaged_clock: false
      unmanaged_reset: false
      reset_connection:
      {
        name: por_aon
        domain: Aon
      }
    }
    {
      name: ext_lc_aon_Aon
      clock_group:
      {
        name: ext
        src: ext
        sw_cg: no
        unique: no
        clocks:
        {
          clk_aon_i: aon
          clk_main_i: main
        }
      }
      clock_connection: clk_aon_i
      unmanaged_clock: false
      unmanaged_reset: false
      reset_connection:
      {
        name: lc_aon
        domain: Aon
      }
    }
    {
      name: secure_lc_main_Main
      clock_group:
      {
        name: secure
        src: top
        sw_cg: no
        unique: no
        clocks:
        {
          clk_main_secure: main
          clk_aon_secure: aon
        }
      }
      clock_connection: clkmgr_clocks_i.clk_main_secure
      unmanaged_clock: false
      unmanaged_reset: false
      reset_connection:
      {
        name: lc_main
        domain: Main
      }
    }
    {
      name: secure_sys_Main
      clock_group:
      {
        name: secure
        src: top
        sw_cg: no
        unique: no
        clocks:
        {
          clk_main_secure: main
          clk_aon_secure: aon
        }
      }
      clock_connection: clkmgr_clocks_i.clk_main_secure
      unmanaged_clock: false
      unmanaged_reset: false
      reset_connection:
      {
        name: sys
        domain: Main
      }
    }
  ]
  outgoing_alert_lpgs: {}
  inter_signal:
  {
    signals:
    [
      {
        name: pwr_ast
        struct: pwr_ast
        package: pwrmgr_pkg
        type: req_rsp
        act: req
        width: 1
        inst_name: pwrmgr
        default: ""
        top_signame: pwrmgr_pwr_ast
        index: -1
      }
      {
        name: pwr_rst
        struct: pwr_rst
        package: pwrmgr_pkg
        type: req_rsp
        act: req
        width: 1
        inst_name: pwrmgr
        default: ""
        end_idx: -1
        top_type: one-to-one
        top_signame: pwrmgr_pwr_rst
        index: -1
      }
      {
        name: pwr_clk
        struct: pwr_clk
        package: pwrmgr_pkg
        type: req_rsp
        act: req
        width: 1
        inst_name: pwrmgr
        default: ""
        end_idx: -1
        top_type: one-to-one
        top_signame: pwrmgr_pwr_clk
        index: -1
      }
      {
        name: pwr_otp
        struct: pwr_otp
        package: pwrmgr_pkg
        type: req_rsp
        act: req
        width: 1
        inst_name: pwrmgr
        default: ""
        end_idx: -1
        top_type: one-to-one
        top_signame: pwrmgr_pwr_otp
        index: -1
        external: true
        conn_type: false
      }
      {
        name: pwr_lc
        struct: pwr_lc
        package: lc_ctrl_pkg
        type: req_rsp
        act: req
        width: 1
        inst_name: pwrmgr
        default: ""
        end_idx: -1
        top_type: one-to-one
        top_signame: pwrmgr_pwr_lc
        index: -1
        external: true
        conn_type: false
      }
      {
        name: pwr_nvm
        struct: pwr_nvm
        package: pwrmgr_pkg
        type: uni
        act: rcv
        width: 1
        inst_name: pwrmgr
        index: -1
      }
      {
        name: esc_rst_tx
        struct: esc_tx
        package: prim_esc_pkg
        type: uni
        act: rcv
        width: 1
        inst_name: pwrmgr
        default: ""
        domain: Aon
        top_signame: alert_handler_esc_tx
        index: 3
      }
      {
        name: esc_rst_rx
        struct: esc_rx
        package: prim_esc_pkg
        type: uni
        act: req
        width: 1
        inst_name: pwrmgr
        default: ""
        domain: Aon
        top_signame: alert_handler_esc_rx
        index: 3
      }
      {
        name: pwr_cpu
        struct: cpu_pwrmgr
        package: rv_core_ibex_pkg
        type: uni
        act: rcv
        width: 1
        inst_name: pwrmgr
        default: ""
        domain: Aon
        top_signame: rv_core_ibex_pwrmgr
        index: -1
        external: true
        conn_type: false
      }
      {
        name: wakeups
        struct: logic
        type: uni
        act: rcv
        width: 1
        inst_name: pwrmgr
        default: ""
        package: ""
        external: true
        conn_type: false
        index: -1
        top_signame: wakeup_main
      }
      {
        name: rstreqs
        struct: logic
        type: uni
        act: rcv
        width: 1
        inst_name: pwrmgr
        default: ""
        package: ""
        end_idx: -1
        top_type: broadcast
        index: -1
      }
      {
        name: ndmreset_req
        struct: logic
        type: uni
        act: rcv
        width: 1
        inst_name: pwrmgr
        default: ""
        package: ""
        domain: Aon
        top_signame: rv_dm_ndmreset_req
        index: -1
        external: true
        conn_type: false
      }
      {
        name: strap
        struct: logic
        type: uni
        act: req
        width: 1
        inst_name: pwrmgr
        default: ""
        package: ""
        end_idx: -1
        top_type: broadcast
        top_signame: pwrmgr_strap
        index: -1
        external: true
        conn_type: false
      }
      {
        name: low_power
        struct: logic
        type: uni
        act: req
        width: 1
        inst_name: pwrmgr
        default: ""
        package: ""
        end_idx: -1
        top_type: broadcast
        index: -1
      }
      {
        name: rom_ctrl
        struct: pwrmgr_data
        package: rom_ctrl_pkg
        type: uni
        act: rcv
        width: 1
        default: rom_ctrl_pkg::PWRMGR_DATA_DEFAULT
        inst_name: pwrmgr
        end_idx: -1
        top_type: broadcast
        top_signame: pwrmgr_rom_ctrl
        index: -1
        external: true
        conn_type: false
      }
      {
        name: fetch_en
        struct: lc_tx
        package: lc_ctrl_pkg
        type: uni
        act: req
        width: 1
        inst_name: pwrmgr
        default: ""
        end_idx: -1
        top_type: broadcast
        top_signame: pwrmgr_fetch_en
        index: -1
        external: true
        conn_type: false
      }
      {
        name: lc_dft_en
        struct: lc_tx
        package: lc_ctrl_pkg
        type: uni
        act: rcv
        width: 1
        inst_name: pwrmgr
        default: ""
        domain: Aon
        top_signame: lc_ctrl_lc_dft_en
        index: -1
        external: true
        conn_type: false
      }
      {
        name: lc_hw_debug_en
        struct: lc_tx
        package: lc_ctrl_pkg
        type: uni
        act: rcv
        width: 1
        inst_name: pwrmgr
        default: ""
        domain: Aon
        top_signame: lc_ctrl_lc_hw_debug_en
        index: -1
        external: true
        conn_type: false
      }
      {
        name: sw_rst_req
        struct: mubi4
        package: prim_mubi_pkg
        type: uni
        act: rcv
        width: 1
        inst_name: pwrmgr
        default: ""
        domain: Aon
        top_signame: rstmgr_sw_rst_req
        index: -1
      }
      {
        name: tl
        struct: tl
        package: tlul_pkg
        type: req_rsp
        act: rsp
        width: 1
        inst_name: pwrmgr
        default: ""
        end_idx: -1
        top_type: one-to-one
        top_signame: pwrmgr_tl
        index: -1
      }
      {
        name: por_n
        desc:
          '''
          Root power on reset signals from ast.
          There is one root reset signal for each core power domain.
          '''
        struct: logic
        type: uni
        act: rcv
        width: 2
        inst_name: rstmgr
        default: ""
        package: ""
        top_signame: rstmgr_por_n
        index: -1
      }
      {
        name: pwr
        desc:
          '''
          Reset request signals from power manager.
          Power manager can request for specific domains of the lc/sys reset tree to assert.
          '''
        struct: pwr_rst
        type: req_rsp
        act: rsp
        width: 1
        inst_name: rstmgr
        default: ""
        package: pwrmgr_pkg
        domain: Aon
        top_signame: pwrmgr_pwr_rst
        index: -1
      }
      {
        name: resets
        desc: Leaf resets fed to the system.
        struct: rstmgr_out
        package: rstmgr_pkg
        type: uni
        act: req
        width: 1
        inst_name: rstmgr
        default: ""
        top_signame: rstmgr_resets
        index: -1
      }
      {
        name: rst_en
        desc: Low-power-group outputs used by alert handler.
        struct: rstmgr_rst_en
        package: rstmgr_pkg
        type: uni
        act: req
        width: 1
        inst_name: rstmgr
        default: ""
        top_signame: rstmgr_rst_en
        index: -1
      }
      {
        name: alert_dump
        desc: Alert handler crash dump information.
        struct: alert_crashdump
        package: alert_handler_pkg
        type: uni
        act: rcv
        width: 1
        inst_name: rstmgr
        default: ""
        domain: Aon
        top_signame: alert_handler_crashdump
        index: -1
      }
      {
        name: cpu_dump
        desc: Main processing element crash dump information.
        struct: cpu_crash_dump
        package: rv_core_ibex_pkg
        type: uni
        act: rcv
        width: 1
        inst_name: rstmgr
        default: ""
        domain: Aon
        top_signame: rv_core_ibex_crash_dump
        index: -1
        external: true
        conn_type: false
      }
      {
        name: sw_rst_req
        desc: Software requested system reset to pwrmgr.
        struct: mubi4
        package: prim_mubi_pkg
        type: uni
        act: req
        width: 1
        inst_name: rstmgr
        default: ""
        end_idx: -1
        top_type: broadcast
        top_signame: rstmgr_sw_rst_req
        index: -1
      }
      {
        name: tl
        struct: tl
        package: tlul_pkg
        type: req_rsp
        act: rsp
        width: 1
        inst_name: rstmgr
        default: ""
        end_idx: -1
        top_type: one-to-one
        top_signame: rstmgr_tl
        index: -1
      }
      {
        name: clocks
        struct: clkmgr_out
        package: clkmgr_pkg
        type: uni
        act: req
        width: 1
        inst_name: clkmgr
        default: ""
        top_signame: clkmgr_clocks
        index: -1
      }
      {
        name: cg_en
        struct: clkmgr_cg_en
        package: clkmgr_pkg
        type: uni
        act: req
        width: 1
        inst_name: clkmgr
        default: ""
        top_signame: clkmgr_cg_en
        index: -1
      }
      {
        name: jitter_en
        struct: mubi4
        package: prim_mubi_pkg
        type: uni
        act: req
        width: 1
        inst_name: clkmgr
        index: -1
      }
      {
        name: pwr
        struct: pwr_clk
        type: req_rsp
        act: rsp
        width: 1
        inst_name: clkmgr
        default: ""
        package: pwrmgr_pkg
        domain: Aon
        top_signame: pwrmgr_pwr_clk
        index: -1
      }
      {
        name: idle
        struct: mubi4
        package: prim_mubi_pkg
        type: uni
        act: rcv
        width: 1
        default: prim_mubi_pkg::MuBi4False
        inst_name: clkmgr
        end_idx: -1
        top_type: broadcast
        index: -1
      }
      {
        name: tl
        struct: tl
        package: tlul_pkg
        type: req_rsp
        act: rsp
        width: 1
        inst_name: clkmgr
        default: ""
        end_idx: -1
        top_type: one-to-one
        top_signame: clkmgr_tl
        index: -1
      }
      {
        name: crashdump
        struct: alert_crashdump
        package: alert_handler_pkg
        type: uni
        act: req
        width: 1
        inst_name: alert_handler
        default: ""
        end_idx: -1
        top_type: broadcast
        top_signame: alert_handler_crashdump
        index: -1
      }
      {
        name: edn
        struct: edn
        package: edn_pkg
        type: req_rsp
        act: req
        width: 1
        inst_name: alert_handler
        default: ""
        domain: Aon
        top_signame: edn0_edn
        index: -1
        external: true
        conn_type: false
      }
      {
        name: esc_rx
        struct: esc_rx
        package: prim_esc_pkg
        type: uni
        act: rcv
        width: 4
        inst_name: alert_handler
        default: ""
        end_idx: -1
        top_type: one-to-N
        top_signame: alert_handler_esc_rx
        index:
        [
          0
          1
          2
        ]
        external: true
        conn_type: true
      }
      {
        name: esc_tx
        struct: esc_tx
        package: prim_esc_pkg
        type: uni
        act: req
        width: 4
        inst_name: alert_handler
        default: ""
        end_idx: -1
        top_type: one-to-N
        top_signame: alert_handler_esc_tx
        index:
        [
          0
          1
          2
        ]
        external: true
        conn_type: true
      }
      {
        name: tl
        struct: tl
        package: tlul_pkg
        type: req_rsp
        act: rsp
        width: 1
        inst_name: alert_handler
        default: ""
        end_idx: -1
        top_type: one-to-one
        top_signame: alert_handler_tl
        index: -1
      }
      {
        name: racl_policies
        desc:
          '''
          Incoming RACL policy vector from a racl_ctrl instance.
          The policy selection vector (parameter) selects the policy for each register.
          '''
        struct: racl_policy_vec
        package: top_racl_pkg
        type: uni
        act: rcv
        width: 1
        inst_name: rv_timer_aon
        index: -1
      }
      {
        name: racl_error
        desc: RACL error log information of this module.
        struct: racl_error_log
        package: top_racl_pkg
        type: uni
        act: req
        width: 1
        inst_name: rv_timer_aon
        index: -1
      }
      {
        name: tl
        struct: tl
        package: tlul_pkg
        type: req_rsp
        act: rsp
        width: 1
        inst_name: rv_timer_aon
        default: ""
        end_idx: -1
        top_type: one-to-one
        top_signame: rv_timer_aon_tl
        index: -1
      }
      {
        name: sram_otp_key
        struct: sram_otp_key
        package: otp_ctrl_pkg
        type: req_rsp
        act: req
        width: 1
        inst_name: sram_ctrl_ret_aon
        default: ""
        domain: Aon
        top_signame: otp_ctrl_sram_otp_key
        index: -1
        external: true
        conn_type: false
      }
      {
        name: ram_cfg
        struct: ram_1p_cfg
        package: prim_ram_1p_pkg
        type: req_rsp
        act: rsp
        width:
        {
          name: NumRamInst
          desc: Number of internal RAM instances. Must be the same as ceil(MemSizeRam / InstSize) .
          param_type: int
          unpacked_dimensions: null
          default: 1
          local: false
          expose: true
          name_top: SramCtrlRetAonNumRamInst
        }
        inst_name: sram_ctrl_ret_aon
        index: -1
      }
      {
        name: lc_escalate_en
        struct: lc_tx
        package: lc_ctrl_pkg
        type: uni
        act: rcv
        width: 1
        default: lc_ctrl_pkg::Off
        inst_name: sram_ctrl_ret_aon
        domain: Aon
        top_signame: lc_ctrl_lc_escalate_en
        index: -1
        external: true
        conn_type: false
      }
      {
        name: lc_hw_debug_en
        struct: lc_tx
        package: lc_ctrl_pkg
        type: uni
        act: rcv
        width: 1
        default: lc_ctrl_pkg::Off
        inst_name: sram_ctrl_ret_aon
        domain: Aon
        top_signame: lc_ctrl_lc_hw_debug_en
        index: -1
        external: true
        conn_type: false
      }
      {
        name: otp_en_sram_ifetch
        struct: mubi8
        package: prim_mubi_pkg
        type: uni
        act: rcv
        width: 1
        default: prim_mubi_pkg::MuBi8False
        inst_name: sram_ctrl_ret_aon
        index: -1
      }
      {
        name: racl_policies
        desc:
          '''
          Incoming RACL policy vector from a racl_ctrl instance.
          The policy selection vector (parameter) selects the policy for each register.
          '''
        struct: racl_policy_vec
        package: top_racl_pkg
        type: uni
        act: rcv
        width: 1
        inst_name: sram_ctrl_ret_aon
        index: -1
      }
      {
        name: racl_error
        desc: RACL error log information of this module.
        struct: racl_error_log
        package: top_racl_pkg
        type: uni
        act: req
        width: 1
        inst_name: sram_ctrl_ret_aon
        index: -1
      }
      {
        name: sram_rerror
        desc: SRAM read error indicating correctable and uncorrectable ECC errors.
        struct: sram_error_t
        package: sram_ctrl_pkg
        type: uni
        act: req
        width: 1
        inst_name: sram_ctrl_ret_aon
        index: -1
      }
      {
        name: regs_tl
        struct: tl
        package: tlul_pkg
        type: req_rsp
        act: rsp
        width: 1
        inst_name: sram_ctrl_ret_aon
        default: ""
        end_idx: -1
        top_type: one-to-one
        top_signame: sram_ctrl_ret_aon_regs_tl
        index: -1
      }
      {
        name: ram_tl
        struct: tl
        package: tlul_pkg
        type: req_rsp
        act: rsp
        width: 1
        inst_name: sram_ctrl_ret_aon
        default: ""
        end_idx: -1
        top_type: one-to-one
        top_signame: sram_ctrl_ret_aon_ram_tl
        index: -1
      }
      {
        name: edn
        desc: Entropy request to the entropy distribution network for LFSR reseeding and ephemeral key derivation.
        struct: edn
        package: edn_pkg
        type: req_rsp
        act: req
        width: 1
        inst_name: otp_ctrl
        default: ""
        domain: Main
        top_signame: edn0_edn
        index: 1
      }
      {
        name: pwr_otp
        desc: Initialization request/acknowledge from/to power manager.
        struct: pwr_otp
        package: pwrmgr_pkg
        type: req_rsp
        act: rsp
        width: 1
        default: "'0"
        inst_name: otp_ctrl
        domain: Main
        top_signame: pwrmgr_pwr_otp
        index: -1
        external: true
        conn_type: false
      }
      {
        name: lc_otp_program
        desc: Life cycle state transition interface.
        struct: lc_otp_program
        package: otp_ctrl_pkg
        type: req_rsp
        act: rsp
        width: 1
        default: "'0"
        inst_name: otp_ctrl
        domain: Main
        top_signame: lc_ctrl_lc_otp_program
        index: -1
      }
      {
        name: otp_lc_data
        desc:
          '''
          Life cycle state output holding the current life cycle state,
          the value of the transition counter and the tokens needed for life cycle transitions.
          '''
        struct: otp_lc_data
        package: otp_ctrl_pkg
        type: uni
        act: req
        width: 1
        default: "'0"
        inst_name: otp_ctrl
        end_idx: -1
        top_type: broadcast
        top_signame: otp_ctrl_otp_lc_data
        index: -1
      }
      {
        name: lc_escalate_en
        desc:
          '''
          Life cycle escalation enable coming from life cycle controller.
          This signal moves all FSMs within OTP into the error state.
          '''
        struct: lc_tx
        package: lc_ctrl_pkg
        type: uni
        act: rcv
        width: 1
        default: lc_ctrl_pkg::Off
        inst_name: otp_ctrl
        domain: Main
        top_signame: lc_ctrl_lc_escalate_en
        index: -1
      }
      {
        name: lc_creator_seed_sw_rw_en
        desc:
          '''
          Provision enable qualifier coming from life cycle controller.
          This signal enables SW read / write access to the RMA_TOKEN and CREATOR_ROOT_KEY_SHARE0 and CREATOR_ROOT_KEY_SHARE1.
          '''
        struct: lc_tx
        package: lc_ctrl_pkg
        type: uni
        act: rcv
        width: 1
        default: lc_ctrl_pkg::Off
        inst_name: otp_ctrl
        domain: Main
        top_signame: lc_ctrl_lc_creator_seed_sw_rw_en
        index: -1
      }
      {
        name: lc_owner_seed_sw_rw_en
        desc:
          '''
          Provision enable qualifier coming from life cycle controller.
          This signal enables SW read / write access to the OWNER_SEED.
          '''
        struct: lc_tx
        package: lc_ctrl_pkg
        type: uni
        act: rcv
        width: 1
        default: lc_ctrl_pkg::Off
        inst_name: otp_ctrl
        domain: Main
        top_signame: lc_ctrl_lc_owner_seed_sw_rw_en
        index: -1
      }
      {
        name: lc_seed_hw_rd_en
        desc:
          '''
          Seed read enable coming from life cycle controller.
          This signal enables HW read access to the CREATOR_ROOT_KEY_SHARE0 and CREATOR_ROOT_KEY_SHARE1.
          '''
        struct: lc_tx
        package: lc_ctrl_pkg
        type: uni
        act: rcv
        width: 1
        default: lc_ctrl_pkg::Off
        inst_name: otp_ctrl
        domain: Main
        top_signame: lc_ctrl_lc_seed_hw_rd_en
        index: -1
      }
      {
        name: lc_rma_state
        desc:
          '''
          This signal states whether the current life cycle is RMA.
          It is used to enable SW read access to (read-locked) partitions in the RMA state.
          '''
        struct: lc_tx
        package: lc_ctrl_pkg
        type: uni
        act: rcv
        width: 1
        default: lc_ctrl_pkg::Off
        inst_name: otp_ctrl
        domain: Main
        top_signame: lc_ctrl_lc_rma_state
        index: -1
      }
      {
        name: lc_check_byp_en
        desc:
          '''
          Life cycle partition check bypass signal.
          This signal causes the life cycle partition to bypass consistency checks during life cycle state transitions in order to prevent spurious consistency check failures.
          '''
        struct: lc_tx
        package: lc_ctrl_pkg
        type: uni
        act: rcv
        width: 1
        default: lc_ctrl_pkg::Off
        inst_name: otp_ctrl
        domain: Main
        top_signame: lc_ctrl_lc_check_byp_en
        index: -1
      }
      {
        name: keymgr_creator_root_key
        desc: Key output to the key manager holding CREATOR_ROOT_KEY_SHARE0 and CREATOR_ROOT_KEY_SHARE1.
        struct: keymgr_dpe_creator_root_key
        package: keymgr_dpe_pkg
        type: uni
        act: req
        width: 1
        default: "'0"
        inst_name: otp_ctrl
        end_idx: -1
        top_type: broadcast
        top_signame: otp_ctrl_keymgr_creator_root_key
        index: -1
      }
      {
        name: keymgr_creator_seed
        desc: Creator seed output to the key manager
        struct: keymgr_dpe_creator_seed
        package: keymgr_dpe_pkg
        type: uni
        act: req
        width: 1
        default: "'0"
        inst_name: otp_ctrl
        end_idx: -1
        top_type: broadcast
        top_signame: otp_ctrl_keymgr_creator_seed
        index: -1
      }
      {
        name: keymgr_owner_seed
        desc: Owner seed output to the key manager
        struct: keymgr_dpe_owner_seed
        package: keymgr_dpe_pkg
        type: uni
        act: req
        width: 1
        default: "'0"
        inst_name: otp_ctrl
        end_idx: -1
        top_type: broadcast
        top_signame: otp_ctrl_keymgr_owner_seed
        index: -1
      }
      {
        name: sram_otp_key
        desc: Array with key derivation interfaces for SRAM scrambling devices.
        struct: sram_otp_key
        package: otp_ctrl_pkg
        type: req_rsp
        act: rsp
        width: 4
        default: "'0"
        inst_name: otp_ctrl
        end_idx: 3
        top_type: partial-one-to-N
        top_signame: otp_ctrl_sram_otp_key
        index: 1
        external: true
        conn_type: true
      }
      {
        name: otbn_otp_key
        desc: Key derivation interface for OTBN scrambling devices.
        struct: otbn_otp_key
        package: otp_ctrl_pkg
        type: req_rsp
        act: rsp
        width: 1
        default: "'0"
        inst_name: otp_ctrl
        end_idx: -1
        top_type: one-to-one
        top_signame: otp_ctrl_otbn_otp_key
        index: -1
      }
      {
        name: otp_broadcast
        desc: Output of the HW partitions with breakout data types.
        struct: otp_broadcast
        package: otp_ctrl_part_pkg
        type: uni
        act: req
        width: 1
        default: "'0"
        inst_name: otp_ctrl
        top_signame: otp_ctrl_otp_broadcast
        index: -1
      }
      {
        name: otp_macro
        desc: Data interface for the OTP macro.
        struct: otp_ctrl_macro
        package: otp_ctrl_macro_pkg
        type: req_rsp
        act: req
        width: 1
        default: "'0"
        inst_name: otp_ctrl
        end_idx: -1
        top_type: one-to-one
        top_signame: otp_ctrl_otp_macro
        index: -1
      }
      {
        name: core_tl
        struct: tl
        package: tlul_pkg
        type: req_rsp
        act: rsp
        width: 1
        inst_name: otp_ctrl
        default: ""
        end_idx: -1
        top_type: one-to-one
        top_signame: otp_ctrl_core_tl
        index: -1
      }
      {
        name: obs_ctrl
        desc: AST observability control signals.
        struct: ast_obs_ctrl
        package: ast_pkg
        type: uni
        act: rcv
        width: 1
        inst_name: otp_macro
        index: -1
      }
      {
        name: otp_obs
        desc: AST observability bus.
        struct: logic
        type: uni
        act: req
        width: 8
        inst_name: otp_macro
        index: -1
      }
      {
        name: pwr_seq
        desc: Power sequencing signals to AST (VDD domain).
        struct: pwr_seq
        package: otp_macro_pkg
        type: uni
        act: req
        width: 1
        default: "'0"
        inst_name: otp_macro
        index: -1
      }
      {
        name: pwr_seq_h
        desc: Power sequencing signals coming from AST (VCC domain).
        struct: pwr_seq
        package: otp_macro_pkg
        type: uni
        act: rcv
        width: 1
        default: "'0"
        inst_name: otp_macro
        index: -1
      }
      {
        name: ext_voltage_h
        struct: ""
        type: io
        act: none
        width: 1
        default: "'0"
        inst_name: otp_macro
        index: -1
      }
      {
        name: lc_dft_en
        desc:
          '''
          Test enable qualifier coming from life cycle controller.
          This signals enables the TL-UL access port.
          '''
        struct: lc_tx
        package: lc_ctrl_pkg
        type: uni
        act: rcv
        width: 1
        default: lc_ctrl_pkg::Off
        inst_name: otp_macro
        domain: Main
        top_signame: lc_ctrl_lc_dft_en
        index: -1
      }
      {
        name: test
        desc: Vendor test control signals from/to the life cycle TAP.
        struct: otp_test
        package: otp_macro_pkg
        type: req_rsp
        act: rsp
        width: 1
        default: "'0"
        inst_name: otp_macro
        domain: Main
        top_signame: lc_ctrl_lc_otp_vendor_test
        index: -1
      }
      {
        name: otp
        desc: Data interface for the OTP macro.
        struct: otp_ctrl_macro
        package: otp_ctrl_macro_pkg
        type: req_rsp
        act: rsp
        width: 1
        default: "'0"
        inst_name: otp_macro
        domain: Main
        top_signame: otp_ctrl_otp_macro
        index: -1
      }
      {
        name: cfg
        struct: otp_cfg
        package: otp_macro_pkg
        type: uni
        act: rcv
        width: 1
        default: "'0"
        inst_name: otp_macro
        index: -1
      }
      {
        name: cfg_rsp
        struct: otp_cfg_rsp
        package: otp_macro_pkg
        type: uni
        act: req
        width: 1
        default: "'0"
        inst_name: otp_macro
        index: -1
      }
      {
        name: racl_policies
        desc:
          '''
          Incoming RACL policy vector from a racl_ctrl instance.
          The policy selection vector (parameter) selects the policy for each register.
          '''
        struct: racl_policy_vec
        package: top_racl_pkg
        type: uni
        act: rcv
        width: 1
        inst_name: otp_macro
        index: -1
      }
      {
        name: racl_error
        desc: RACL error log information of this module.
        struct: racl_error_log
        package: top_racl_pkg
        type: uni
        act: req
        width: 1
        inst_name: otp_macro
        index: -1
      }
      {
        name: prim_tl
        struct: tl
        package: tlul_pkg
        type: req_rsp
        act: rsp
        width: 1
        inst_name: otp_macro
        default: ""
        end_idx: -1
        top_type: one-to-one
        top_signame: otp_macro_prim_tl
        index: -1
      }
      {
        name: jtag
        struct: jtag
        package: jtag_pkg
        type: req_rsp
        act: rsp
        width: 1
        inst_name: lc_ctrl
        index: -1
      }
      {
        name: esc_scrap_state0_tx
        struct: esc_tx
        package: prim_esc_pkg
        type: uni
        act: rcv
        width: 1
        inst_name: lc_ctrl
        default: ""
        domain: Main
        top_signame: alert_handler_esc_tx
        index: 1
        external: true
        conn_type: false
      }
      {
        name: esc_scrap_state0_rx
        struct: esc_rx
        package: prim_esc_pkg
        type: uni
        act: req
        width: 1
        inst_name: lc_ctrl
        default: ""
        domain: Main
        top_signame: alert_handler_esc_rx
        index: 1
        external: true
        conn_type: false
      }
      {
        name: esc_scrap_state1_tx
        struct: esc_tx
        package: prim_esc_pkg
        type: uni
        act: rcv
        width: 1
        inst_name: lc_ctrl
        default: ""
        domain: Main
        top_signame: alert_handler_esc_tx
        index: 2
        external: true
        conn_type: false
      }
      {
        name: esc_scrap_state1_rx
        struct: esc_rx
        package: prim_esc_pkg
        type: uni
        act: req
        width: 1
        inst_name: lc_ctrl
        default: ""
        domain: Main
        top_signame: alert_handler_esc_rx
        index: 2
        external: true
        conn_type: false
      }
      {
        name: pwr_lc
        struct: pwr_lc
        package: lc_ctrl_pkg
        type: req_rsp
        act: rsp
        width: 1
        inst_name: lc_ctrl
        default: ""
        domain: Main
        top_signame: pwrmgr_pwr_lc
        index: -1
        external: true
        conn_type: false
      }
      {
        name: lc_otp_vendor_test
        struct: otp_test
        package: otp_macro_pkg
        type: req_rsp
        act: req
        width: 1
        default: "'0"
        inst_name: lc_ctrl
        end_idx: -1
        top_type: one-to-one
        top_signame: lc_ctrl_lc_otp_vendor_test
        index: -1
      }
      {
        name: otp_lc_data
        struct: otp_lc_data
        package: otp_ctrl_pkg
        type: uni
        act: rcv
        width: 1
        default: otp_ctrl_pkg::OTP_LC_DATA_DEFAULT
        inst_name: lc_ctrl
        domain: Main
        top_signame: otp_ctrl_otp_lc_data
        index: -1
      }
      {
        name: lc_otp_program
        struct: lc_otp_program
        package: otp_ctrl_pkg
        type: req_rsp
        act: req
        width: 1
        default: "'0"
        inst_name: lc_ctrl
        end_idx: -1
        top_type: one-to-one
        top_signame: lc_ctrl_lc_otp_program
        index: -1
      }
      {
        name: kmac_data
        struct: app
        package: kmac_pkg
        type: req_rsp
        act: req
        width: 1
        default: "'0"
        inst_name: lc_ctrl
        domain: Main
        top_signame: kmac_app
        index: 1
      }
      {
        name: lc_init_done
        desc:
          '''
          A signal that is On after lifecycle initialization is done.
          This signal is On when lifecycle initialization is complete and life cycle controller broadcast signals are valid.
          '''
        struct: lc_tx
        package: lc_ctrl_pkg
        type: uni
        act: req
        width: 1
        default: lc_ctrl_pkg::Off
        inst_name: lc_ctrl
        end_idx: -1
        top_type: broadcast
        top_signame: lc_ctrl_lc_init_done
        index: -1
      }
      {
        name: lc_raw_test_rma
        struct: lc_tx
        package: lc_ctrl_pkg
        type: uni
        act: req
        width: 1
        default: lc_ctrl_pkg::Off
        inst_name: lc_ctrl
        end_idx: -1
        top_type: broadcast
        index: -1
      }
      {
        name: lc_dft_en
        struct: lc_tx
        package: lc_ctrl_pkg
        type: uni
        act: req
        width: 1
        default: lc_ctrl_pkg::Off
        inst_name: lc_ctrl
        end_idx: -1
        top_type: broadcast
        top_signame: lc_ctrl_lc_dft_en
        index: -1
        external: true
        conn_type: true
      }
      {
        name: lc_nvm_debug_en
        struct: lc_tx
        package: lc_ctrl_pkg
        type: uni
        act: req
        width: 1
        default: lc_ctrl_pkg::Off
        inst_name: lc_ctrl
        top_signame: lc_ctrl_lc_nvm_debug_en
        index: -1
      }
      {
        name: lc_hw_debug_clr
        desc:
          '''
          Clear HW debug functionality.
          This signal is On when `lc_hw_debug_en` turns Off outside a reset of `lc_ctrl`.
          Flops storing the value of `lc_hw_debug_en` (see below) must be cleared when this signal is On.
          '''
        struct: lc_tx
        package: lc_ctrl_pkg
        type: uni
        act: req
        width: 1
        default: lc_ctrl_pkg::Off
        inst_name: lc_ctrl
        end_idx: -1
        top_type: broadcast
        top_signame: lc_ctrl_lc_hw_debug_clr
        index: -1
      }
      {
        name: lc_hw_debug_en
        desc:
          '''
          Enable HW debug functionality; see `HW_DEBUG_EN` in the Theory of Operation doc for details.

          This signal is Off while lc_ctrl is in reset.
          In order to prevent a JTAG disconnect during non-debug-module (NDM) reset, this signal should be flopped outside the NDM reset domain.
          Such a flop must be cleared when `lc_hw_debug_clr` is On; see above.
          '''
        struct: lc_tx
        package: lc_ctrl_pkg
        type: uni
        act: req
        width: 1
        default: lc_ctrl_pkg::Off
        inst_name: lc_ctrl
        end_idx: -1
        top_type: broadcast
        top_signame: lc_ctrl_lc_hw_debug_en
        index: -1
        external: true
        conn_type: true
      }
      {
        name: lc_cpu_en
        struct: lc_tx
        package: lc_ctrl_pkg
        type: uni
        act: req
        width: 1
        default: lc_ctrl_pkg::Off
        inst_name: lc_ctrl
        end_idx: -1
        top_type: broadcast
        top_signame: lc_ctrl_lc_cpu_en
        index: -1
      }
      {
        name: lc_keymgr_en
        struct: lc_tx
        package: lc_ctrl_pkg
        type: uni
        act: req
        width: 1
        default: lc_ctrl_pkg::Off
        inst_name: lc_ctrl
        end_idx: -1
        top_type: broadcast
        top_signame: lc_ctrl_lc_keymgr_en
        index: -1
      }
      {
        name: lc_escalate_en
        struct: lc_tx
        package: lc_ctrl_pkg
        type: uni
        act: req
        width: 1
        default: lc_ctrl_pkg::Off
        inst_name: lc_ctrl
        end_idx: -1
        top_type: broadcast
        top_signame: lc_ctrl_lc_escalate_en
        index: -1
        external: true
        conn_type: true
      }
      {
        name: lc_clk_byp_req
        struct: lc_tx
        package: lc_ctrl_pkg
        type: uni
        act: req
        width: 1
        default: lc_ctrl_pkg::Off
        inst_name: lc_ctrl
        domain: Main
        top_signame: lc_ctrl_lc_clk_byp_ack
        index: -1
      }
      {
        name: lc_clk_byp_ack
        struct: lc_tx
        package: lc_ctrl_pkg
        type: uni
        act: rcv
        width: 1
        default: lc_ctrl_pkg::Off
        inst_name: lc_ctrl
        end_idx: -1
        top_type: broadcast
        top_signame: lc_ctrl_lc_clk_byp_ack
        index: -1
      }
      {
        name: lc_nvm_rma_req
        struct: lc_tx
        package: lc_ctrl_pkg
        type: uni
        act: req
        width: 1
        default: lc_ctrl_pkg::Off
        inst_name: lc_ctrl
        end_idx: -1
        top_type: broadcast
        top_signame: lc_ctrl_lc_nvm_rma_req
        index: -1
      }
      {
        name: lc_nvm_rma_ack
        struct: lc_tx
        package: lc_ctrl_pkg
        type: uni
        act: rcv
        width: 2
        default: lc_ctrl_pkg::On
        inst_name: lc_ctrl
        domain: Main
        top_signame: otbn_lc_rma_ack
        index: -1
      }
      {
        name: lc_nvm_rma_seed
        struct: lc_nvm_rma_seed
        package: lc_ctrl_pkg
        type: uni
        act: req
        width: 1
        default: "'0"
        inst_name: lc_ctrl
        index: -1
      }
      {
        name: lc_check_byp_en
        struct: lc_tx
        package: lc_ctrl_pkg
        type: uni
        act: req
        width: 1
        default: lc_ctrl_pkg::Off
        inst_name: lc_ctrl
        end_idx: -1
        top_type: broadcast
        top_signame: lc_ctrl_lc_check_byp_en
        index: -1
      }
      {
        name: lc_creator_seed_sw_rw_en
        struct: lc_tx
        package: lc_ctrl_pkg
        type: uni
        act: req
        width: 1
        default: lc_ctrl_pkg::Off
        inst_name: lc_ctrl
        end_idx: -1
        top_type: broadcast
        top_signame: lc_ctrl_lc_creator_seed_sw_rw_en
        index: -1
      }
      {
        name: lc_owner_seed_sw_rw_en
        struct: lc_tx
        package: lc_ctrl_pkg
        type: uni
        act: req
        width: 1
        default: lc_ctrl_pkg::Off
        inst_name: lc_ctrl
        end_idx: -1
        top_type: broadcast
        top_signame: lc_ctrl_lc_owner_seed_sw_rw_en
        index: -1
      }
      {
        name: lc_iso_part_sw_rd_en
        struct: lc_tx
        package: lc_ctrl_pkg
        type: uni
        act: req
        width: 1
        default: lc_ctrl_pkg::Off
        inst_name: lc_ctrl
        index: -1
      }
      {
        name: lc_iso_part_sw_wr_en
        struct: lc_tx
        package: lc_ctrl_pkg
        type: uni
        act: req
        width: 1
        default: lc_ctrl_pkg::Off
        inst_name: lc_ctrl
        index: -1
      }
      {
        name: lc_seed_hw_rd_en
        struct: lc_tx
        package: lc_ctrl_pkg
        type: uni
        act: req
        width: 1
        default: lc_ctrl_pkg::Off
        inst_name: lc_ctrl
        end_idx: -1
        top_type: broadcast
        top_signame: lc_ctrl_lc_seed_hw_rd_en
        index: -1
      }
      {
        name: lc_rma_state
        struct: lc_tx
        package: lc_ctrl_pkg
        type: uni
        act: req
        width: 1
        default: lc_ctrl_pkg::Off
        inst_name: lc_ctrl
        end_idx: -1
        top_type: broadcast
        top_signame: lc_ctrl_lc_rma_state
        index: -1
      }
      {
        name: lc_keymgr_div
        struct: lc_keymgr_div
        package: lc_ctrl_pkg
        type: uni
        act: req
        width: 1
        default: "'0"
        inst_name: lc_ctrl
        end_idx: -1
        top_type: broadcast
        top_signame: lc_ctrl_lc_keymgr_div
        index: -1
      }
      {
        name: otp_device_id
        struct: otp_device_id
        package: otp_ctrl_pkg
        type: uni
        act: rcv
        width: 1
        default: "'0"
        inst_name: lc_ctrl
        top_signame: lc_ctrl_otp_device_id
        index: -1
      }
      {
        name: otp_manuf_state
        struct: otp_manuf_state
        package: otp_ctrl_pkg
        type: uni
        act: rcv
        width: 1
        default: "'0"
        inst_name: lc_ctrl
        top_signame: lc_ctrl_otp_manuf_state
        index: -1
      }
      {
        name: hw_rev
        struct: lc_hw_rev
        package: lc_ctrl_pkg
        type: uni
        act: req
        width: 1
        default: "'0"
        inst_name: lc_ctrl
        index: -1
      }
      {
        name: strap_en_override
        desc:
          '''
          This signal transitions from 0 -> 1 by the lc_ctrl manager after volatile RAW_UNLOCK in order to re-sample the HW straps.
          The signal stays at 1 until reset.
          Note that this is only used in test chips when SecVolatileRawUnlockEn = 1.
          Otherwise this signal is tied off to 0.
          '''
        struct: logic
        type: uni
        act: req
        width: 1
        default: 1'b0
        inst_name: lc_ctrl
        package: ""
        end_idx: -1
        top_type: broadcast
        top_signame: lc_ctrl_strap_en_override
        index: -1
      }
      {
        name: regs_tl
        struct: tl
        package: tlul_pkg
        type: req_rsp
        act: rsp
        width: 1
        inst_name: lc_ctrl
        default: ""
        end_idx: -1
        top_type: one-to-one
        top_signame: lc_ctrl_regs_tl
        index: -1
      }
      {
        name: dmi_tl
        struct: tl
        package: tlul_pkg
        type: req_rsp
        act: rsp
        width: 1
        inst_name: lc_ctrl
        default: ""
        end_idx: -1
        top_type: one-to-one
        top_signame: lc_ctrl_dmi_tl
        index: -1
      }
      {
        name: next_dm_addr
        desc:
          '''
          32bit word address of the next debug module.
          Set to 0x0 if this is the last debug module in the chain.
          '''
        struct: next_dm_addr
        package: rv_dm_pkg
        type: uni
        act: rcv
        width: 1
        default: "'0"
        inst_name: rv_dm
        index: -1
      }
      {
        name: jtag
        desc: JTAG signals for the RISC-V TAP.
        struct: jtag
        package: jtag_pkg
        type: req_rsp
        act: rsp
        width: 1
        inst_name: rv_dm
        index: -1
      }
      {
        name: lc_init_done
        desc: Lifecycle initialization done signal coming from life cycle controller.
        struct: lc_tx
        package: lc_ctrl_pkg
        type: uni
        act: rcv
        width: 1
        default: lc_ctrl_pkg::Off
        inst_name: rv_dm
        domain: Main
        top_signame: lc_ctrl_lc_init_done
        index: -1
      }
      {
        name: lc_hw_debug_clr
        desc:
          '''
          Multibit life cycle hardware debug clear signal coming from life cycle controller,
          asserted when the hardware debug mechanism was enabled and gets disabled.
          '''
        struct: lc_tx
        package: lc_ctrl_pkg
        type: uni
        act: rcv
        width: 1
        default: lc_ctrl_pkg::Off
        inst_name: rv_dm
        domain: Main
        top_signame: lc_ctrl_lc_hw_debug_clr
        index: -1
      }
      {
        name: lc_hw_debug_en
        desc:
          '''
          Multibit life cycle hardware debug enable signal coming from life cycle controller,
          asserted when the hardware debug mechanisms are enabled in the system.
          '''
        struct: lc_tx
        package: lc_ctrl_pkg
        type: uni
        act: rcv
        width: 1
        default: lc_ctrl_pkg::Off
        inst_name: rv_dm
        domain: Main
        top_signame: lc_ctrl_lc_hw_debug_en
        index: -1
      }
      {
        name: lc_dft_en
        desc:
          '''
          Multibit life cycle hardware debug enable signal coming from life cycle controller,
          asserted when the DFT mechanisms are enabled in the system.
          '''
        struct: lc_tx
        package: lc_ctrl_pkg
        type: uni
        act: rcv
        width: 1
        default: lc_ctrl_pkg::Off
        inst_name: rv_dm
        domain: Main
        top_signame: lc_ctrl_lc_dft_en
        index: -1
      }
      {
        name: pinmux_hw_debug_en
        desc:
          '''
          Multibit life cycle hardware debug enable signal coming from pinmux.
          This is a latched version of the lc_hw_debug_en signal and is only used to
          gate the JTAG / TAP side of the RV_DM. It is used to keep a debug session live
          while the rest of the system undergoes an NDM reset.
          '''
        struct: lc_tx
        package: lc_ctrl_pkg
        type: uni
        act: rcv
        width: 1
        default: lc_ctrl_pkg::Off
        inst_name: rv_dm
        index: -1
      }
      {
        name: otp_dis_rv_dm_late_debug
        struct: mubi8
        package: prim_mubi_pkg
        type: uni
        act: rcv
        width: 1
        default: prim_mubi_pkg::MuBi8False
        inst_name: rv_dm
        top_signame: rv_dm_otp_dis_rv_dm_late_debug
        index: -1
      }
      {
        name: unavailable
        desc:
          '''
          This signal indicates to the debug module that the main processor is not available
          for debug (e.g. due to a low-power state).
          '''
        struct: logic
        type: uni
        act: rcv
        width: 1
        default: 1'b0
        inst_name: rv_dm
        index: -1
      }
      {
        name: ndmreset_req
        desc: Non-debug module reset request going to the system reset infrastructure.
        struct: logic
        type: uni
        act: req
        width: 1
        inst_name: rv_dm
        default: ""
        package: ""
        end_idx: -1
        top_type: broadcast
        top_signame: rv_dm_ndmreset_req
        index: -1
        external: true
        conn_type: false
      }
      {
        name: dmactive
        desc:
          '''
          This signal indicates whether the debug module is active and can be used to prevent
          power down of the core and bus-attached peripherals.
          '''
        struct: logic
        type: uni
        act: req
        width: 1
        inst_name: rv_dm
        index: -1
      }
      {
        name: debug_req
        desc: This is the debug request interrupt going to the main processor.
        struct: logic [rv_dm_reg_pkg::NrHarts-1:0]
        type: uni
        act: req
        width: 1
        inst_name: rv_dm
        default: ""
        package: ""
        end_idx: -1
        top_type: broadcast
        top_signame: rv_dm_debug_req
        index: -1
      }
      {
        name: lc_escalate_en
        desc:
          '''
          Escalation enable signal coming from life cycle controller, used for invalidating
          the latched lc_hw_debug_en state inside the strap sampling logic.
          '''
        struct: lc_tx
        package: lc_ctrl_pkg
        type: uni
        act: rcv
        width: 1
        default: lc_ctrl_pkg::Off
        inst_name: rv_dm
        domain: Main
        top_signame: lc_ctrl_lc_escalate_en
        index: -1
      }
      {
        name: lc_check_byp_en
        desc:
          '''
          Check bypass enable signal coming from life cycle controller, used for invalidating
          the latched lc_hw_debug_en state inside the strap sampling logic. This signal is asserted
          whenever the life cycle controller performs a life cycle transition. Its main use is
          to skip any background checks inside the life cycle partition of the OTP controller while
          a life cycle transition is in progress.
          '''
        struct: lc_tx
        package: lc_ctrl_pkg
        type: uni
        act: rcv
        width: 1
        default: lc_ctrl_pkg::Off
        inst_name: rv_dm
        domain: Main
        top_signame: lc_ctrl_lc_check_byp_en
        index: -1
      }
      {
        name: strap_en
        desc: This signal is pulsed high by the power manager after reset in order to sample the HW straps.
        struct: logic
        type: uni
        act: rcv
        width: 1
        default: 1'b0
        inst_name: rv_dm
        package: ""
        domain: Main
        top_signame: pwrmgr_strap
        index: -1
        external: true
        conn_type: false
      }
      {
        name: strap_en_override
        desc:
          '''
          This signal transitions from 0 -> 1 by the lc_ctrl manager after volatile RAW_UNLOCK in order to re-sample the HW straps.
          The signal must stay at 1 until reset.
          Note that this is only used in test chips when SecVolatileRawUnlockEn = 1.
          Otherwise this signal is unused.
          '''
        struct: logic
        type: uni
        act: rcv
        width: 1
        default: 1'b0
        inst_name: rv_dm
        package: ""
        domain: Main
        top_signame: lc_ctrl_strap_en_override
        index: -1
      }
      {
        name: racl_policies
        desc:
          '''
          Incoming RACL policy vector from a racl_ctrl instance.
          The policy selection vector (parameter) selects the policy for each register.
          '''
        struct: racl_policy_vec
        package: top_racl_pkg
        type: uni
        act: rcv
        width: 1
        inst_name: rv_dm
        index: -1
      }
      {
        name: racl_error
        desc: RACL error log information of this module.
        struct: racl_error_log
        package: top_racl_pkg
        type: uni
        act: req
        width: 1
        inst_name: rv_dm
        index: -1
      }
      {
        name: sba_tl_h
        struct: tl
        package: tlul_pkg
        type: req_rsp
        act: req
        width: 1
        inst_name: rv_dm
        default: ""
        domain: Main
        top_signame: main_tl_rv_dm__sba
        index: -1
      }
      {
        name: regs_tl_d
        struct: tl
        package: tlul_pkg
        type: req_rsp
        act: rsp
        width: 1
        inst_name: rv_dm
        default: ""
        end_idx: -1
        top_type: one-to-one
        top_signame: rv_dm_regs_tl_d
        index: -1
      }
      {
        name: mem_tl_d
        struct: tl
        package: tlul_pkg
        type: req_rsp
        act: rsp
        width: 1
        inst_name: rv_dm
        default: ""
        end_idx: -1
        top_type: one-to-one
        top_signame: rv_dm_mem_tl_d
        index: -1
      }
      {
        name: dbg_tl_d
        struct: tl
        package: tlul_pkg
        type: req_rsp
        act: rsp
        width: 1
        inst_name: rv_dm
        default: ""
        end_idx: -1
        top_type: one-to-one
        top_signame: rv_dm_dbg_tl_d
        index: -1
      }
      {
        name: irq
        struct: logic
        type: uni
        act: req
        width: 1
        inst_name: rv_plic
        default: ""
        package: ""
        end_idx: -1
        top_type: broadcast
        top_signame: rv_plic_irq
        index: -1
      }
      {
        name: irq_id
        struct: logic
        type: uni
        act: req
        width: 1
        inst_name: rv_plic
        index: -1
      }
      {
        name: msip
        struct: logic
        type: uni
        act: req
        width: 1
        inst_name: rv_plic
        default: ""
        package: ""
        end_idx: -1
        top_type: broadcast
        top_signame: rv_plic_msip
        index: -1
      }
      {
        name: tl
        struct: tl
        package: tlul_pkg
        type: req_rsp
        act: rsp
        width: 1
        inst_name: rv_plic
        default: ""
        end_idx: -1
        top_type: one-to-one
        top_signame: rv_plic_tl
        index: -1
      }
      {
        name: racl_policies
        desc:
          '''
          Incoming RACL policy vector from a racl_ctrl instance.
          The policy selection vector (parameter) selects the policy for each register.
          '''
        struct: racl_policy_vec
        package: top_racl_pkg
        type: uni
        act: rcv
        width: 1
        inst_name: rv_timer
        index: -1
      }
      {
        name: racl_error
        desc: RACL error log information of this module.
        struct: racl_error_log
        package: top_racl_pkg
        type: uni
        act: req
        width: 1
        inst_name: rv_timer
        index: -1
      }
      {
        name: tl
        struct: tl
        package: tlul_pkg
        type: req_rsp
        act: rsp
        width: 1
        inst_name: rv_timer
        default: ""
        end_idx: -1
        top_type: one-to-one
        top_signame: rv_timer_tl
        index: -1
      }
      {
        name: idle
        struct: mubi4
        package: prim_mubi_pkg
        type: uni
        act: req
        width: 1
        inst_name: aes
        index: -1
      }
      {
        name: output_valid
        struct: logic
        type: uni
        act: req
        width: 1
        inst_name: aes
        index: -1
      }
      {
        name: input_ready
        struct: logic
        type: uni
        act: req
        width: 1
        inst_name: aes
        index: -1
      }
      {
        name: lc_escalate_en
        struct: lc_tx
        package: lc_ctrl_pkg
        type: uni
        act: rcv
        width: 1
        default: lc_ctrl_pkg::Off
        inst_name: aes
        domain: Main
        top_signame: lc_ctrl_lc_escalate_en
        index: -1
      }
      {
        name: edn
        struct: edn
        package: edn_pkg
        type: req_rsp
        act: req
        width: 1
        inst_name: aes
        default: ""
        domain: Main
        top_signame: edn0_edn
        index: 4
      }
      {
        name: keymgr_key
        struct: hw_key_req
        package: keymgr_pkg
        type: uni
        act: rcv
        width: 1
        inst_name: aes
        default: ""
        domain: Main
        top_signame: keymgr_dpe_aes_key
        index: -1
      }
      {
        name: tl
        struct: tl
        package: tlul_pkg
        type: req_rsp
        act: rsp
        width: 1
        inst_name: aes
        default: ""
        end_idx: -1
        top_type: one-to-one
        top_signame: aes_tl
        index: -1
      }
      {
        name: idle
        struct: mubi4
        package: prim_mubi_pkg
        type: uni
        act: req
        width: 1
        inst_name: hmac
        index: -1
      }
      {
        name: tl
        struct: tl
        package: tlul_pkg
        type: req_rsp
        act: rsp
        width: 1
        inst_name: hmac
        default: ""
        end_idx: -1
        top_type: one-to-one
        top_signame: hmac_tl
        index: -1
      }
      {
        name: keymgr_key
        struct: hw_key_req
        package: keymgr_pkg
        type: uni
        act: rcv
        width: 1
        inst_name: kmac
        default: ""
        domain: Main
        top_signame: keymgr_dpe_kmac_key
        index: -1
      }
      {
        name: app
        struct: app
        package: kmac_pkg
        type: req_rsp
        act: rsp
        width:
        {
          name: NumAppIntf
          desc: Number of application interfaces
          param_type: int
          unpacked_dimensions: null
          default: 4
          local: false
          expose: true
          name_top: KmacNumAppIntf
        }
        default: kmac_pkg::APP_REQ_DEFAULT
        inst_name: kmac
        end_idx: -1
        top_type: one-to-N
        top_signame: kmac_app
        index: -1
      }
      {
        name: entropy
        struct: edn
        package: edn_pkg
        type: req_rsp
        act: req
        width: 1
        inst_name: kmac
        default: ""
        domain: Main
        top_signame: edn0_edn
        index: 2
      }
      {
        name: idle
        struct: mubi4
        package: prim_mubi_pkg
        type: uni
        act: req
        width: 1
        inst_name: kmac
        index: -1
      }
      {
        name: en_masking
        struct: logic
        type: uni
        act: req
        width: 1
        inst_name: kmac
        default: ""
        package: ""
        end_idx: -1
        top_type: broadcast
        top_signame: kmac_en_masking
        index: -1
      }
      {
        name: lc_escalate_en
        struct: lc_tx
        package: lc_ctrl_pkg
        type: uni
        act: rcv
        width: 1
        default: lc_ctrl_pkg::Off
        inst_name: kmac
        domain: Main
        top_signame: lc_ctrl_lc_escalate_en
        index: -1
      }
      {
        name: tl
        struct: tl
        package: tlul_pkg
        type: req_rsp
        act: rsp
        width: 1
        inst_name: kmac
        default: ""
        end_idx: -1
        top_type: one-to-one
        top_signame: kmac_tl
        index: -1
      }
      {
        name: otbn_otp_key
        struct: otbn_otp_key
        package: otp_ctrl_pkg
        type: req_rsp
        act: req
        width: 1
        default: "'0"
        inst_name: otbn
        domain: Main
        top_signame: otp_ctrl_otbn_otp_key
        index: -1
      }
      {
        name: edn_rnd
        struct: edn
        package: edn_pkg
        type: req_rsp
        act: req
        width: 1
        inst_name: otbn
        default: ""
        domain: Main
        top_signame: edn1_edn
        index: 0
      }
      {
        name: edn_urnd
        struct: edn
        package: edn_pkg
        type: req_rsp
        act: req
        width: 1
        inst_name: otbn
        default: ""
        domain: Main
        top_signame: edn0_edn
        index: 5
      }
      {
        name: idle
        struct: mubi4
        package: prim_mubi_pkg
        type: uni
        act: req
        width: 1
        inst_name: otbn
        index: -1
      }
      {
        name: ram_cfg_imem
        struct: ram_1p_cfg
        package: prim_ram_1p_pkg
        type: req_rsp
        act: rsp
        width: 1
        inst_name: otbn
        index: -1
      }
      {
        name: ram_cfg_dmem
        struct: ram_1p_cfg
        package: prim_ram_1p_pkg
        type: req_rsp
        act: rsp
        width: 1
        inst_name: otbn
        index: -1
      }
      {
        name: lc_escalate_en
        struct: lc_tx
        package: lc_ctrl_pkg
        type: uni
        act: rcv
        width: 1
        default: lc_ctrl_pkg::Off
        inst_name: otbn
        domain: Main
        top_signame: lc_ctrl_lc_escalate_en
        index: -1
      }
      {
        name: lc_rma_req
        struct: lc_tx
        package: lc_ctrl_pkg
        type: uni
        act: rcv
        width: 1
        default: lc_ctrl_pkg::Off
        inst_name: otbn
        domain: Main
        top_signame: lc_ctrl_lc_nvm_rma_req
        index: -1
      }
      {
        name: lc_rma_ack
        struct: lc_tx
        package: lc_ctrl_pkg
        type: uni
        act: req
        width: 1
        default: lc_ctrl_pkg::Off
        inst_name: otbn
        end_idx: -1
        top_type: broadcast
        top_signame: otbn_lc_rma_ack
        index: -1
      }
      {
        name: keymgr_key
        struct: otbn_key_req
        package: keymgr_pkg
        type: uni
        act: rcv
        width: 1
        inst_name: otbn
        default: ""
        domain: Main
        top_signame: keymgr_dpe_otbn_key
        index: -1
      }
      {
        name: kmac_data
        struct: app
        package: kmac_pkg
        type: req_rsp
        act: req
        width: 1
        inst_name: otbn
        index: -1
      }
      {
        name: tl
        struct: tl
        package: tlul_pkg
        type: req_rsp
        act: rsp
        width: 1
        inst_name: otbn
        default: ""
        end_idx: -1
        top_type: one-to-one
        top_signame: otbn_tl
        index: -1
      }
      {
        name: edn
        struct: edn
        package: edn_pkg
        type: req_rsp
        act: req
        width: 1
        inst_name: keymgr_dpe
        default: ""
        domain: Main
        top_signame: edn0_edn
        index: 0
      }
      {
        name: aes_key
        struct: hw_key_req
        package: keymgr_pkg
        type: uni
        act: req
        width: 1
        inst_name: keymgr_dpe
        default: ""
        end_idx: -1
        top_type: broadcast
        top_signame: keymgr_dpe_aes_key
        index: -1
      }
      {
        name: kmac_key
        struct: hw_key_req
        package: keymgr_pkg
        type: uni
        act: req
        width: 1
        inst_name: keymgr_dpe
        default: ""
        end_idx: -1
        top_type: broadcast
        top_signame: keymgr_dpe_kmac_key
        index: -1
      }
      {
        name: otbn_key
        struct: otbn_key_req
        package: keymgr_pkg
        type: uni
        act: req
        width: 1
        inst_name: keymgr_dpe
        default: ""
        end_idx: -1
        top_type: broadcast
        top_signame: keymgr_dpe_otbn_key
        index: -1
      }
      {
        name: kmac_data
        struct: app
        package: kmac_pkg
        type: req_rsp
        act: req
        width: 1
        inst_name: keymgr_dpe
        default: ""
        domain: Main
        top_signame: kmac_app
        index: 0
      }
      {
        name: creator_root_key
        struct: keymgr_dpe_creator_root_key
        package: keymgr_dpe_pkg
        type: uni
        act: rcv
        width: 1
        inst_name: keymgr_dpe
        default: ""
        domain: Main
        top_signame: otp_ctrl_keymgr_creator_root_key
        index: -1
      }
      {
        name: creator_seed
        struct: keymgr_dpe_creator_seed
        package: keymgr_dpe_pkg
        type: uni
        act: rcv
        width: 1
        inst_name: keymgr_dpe
        default: ""
        domain: Main
        top_signame: otp_ctrl_keymgr_creator_seed
        index: -1
      }
      {
        name: owner_seed
        struct: keymgr_dpe_owner_seed
        package: keymgr_dpe_pkg
        type: uni
        act: rcv
        width: 1
        inst_name: keymgr_dpe
        default: ""
        domain: Main
        top_signame: otp_ctrl_keymgr_owner_seed
        index: -1
      }
      {
        name: device_id
        struct: keymgr_dpe_device_id
        package: keymgr_dpe_pkg
        type: uni
        act: rcv
        width: 1
        inst_name: keymgr_dpe
        default: ""
        top_signame: keymgr_dpe_device_id
        index: -1
      }
      {
        name: lc_keymgr_en
        struct: lc_tx
        package: lc_ctrl_pkg
        type: uni
        act: rcv
        width: 1
        default: lc_ctrl_pkg::On
        inst_name: keymgr_dpe
        domain: Main
        top_signame: lc_ctrl_lc_keymgr_en
        index: -1
      }
      {
        name: lc_keymgr_div
        struct: lc_keymgr_div
        package: lc_ctrl_pkg
        type: uni
        act: rcv
        width: 1
        inst_name: keymgr_dpe
        default: ""
        domain: Main
        top_signame: lc_ctrl_lc_keymgr_div
        index: -1
      }
      {
        name: rom_digest
        struct: keymgr_data
        package: rom_ctrl_pkg
        type: uni
        act: rcv
        width:
        {
          name: NumRomDigestInputs
          desc: Number of digest inputs from ROM_CTRL
          param_type: int
          unpacked_dimensions: null
          default: 2
          local: false
          expose: true
          name_top: KeymgrDpeNumRomDigestInputs
        }
        default: rom_ctrl_pkg::KEYMGR_DATA_DEFAULT
        inst_name: keymgr_dpe
        end_idx: -1
        top_type: broadcast
        top_signame: keymgr_dpe_rom_digest
        index: -1
      }
      {
        name: kmac_en_masking
        struct: logic
        type: uni
        act: rcv
        width: 1
        inst_name: keymgr_dpe
        default: ""
        package: ""
        domain: Main
        top_signame: kmac_en_masking
        index: -1
      }
      {
        name: tl
        struct: tl
        package: tlul_pkg
        type: req_rsp
        act: rsp
        width: 1
        inst_name: keymgr_dpe
        default: ""
        end_idx: -1
        top_type: one-to-one
        top_signame: keymgr_dpe_tl
        index: -1
      }
      {
        name: csrng_cmd
        struct: csrng
        package: csrng_pkg
        type: req_rsp
        act: rsp
        width: 2
        inst_name: csrng
        default: ""
        end_idx: -1
        top_type: one-to-N
        top_signame: csrng_csrng_cmd
        index: -1
      }
      {
        name: entropy_src_hw_if
        struct: entropy_src_hw_if
        package: entropy_src_pkg
        type: req_rsp
        act: req
        width: 1
        inst_name: csrng
        default: ""
        end_idx: -1
        top_type: one-to-one
        top_signame: csrng_entropy_src_hw_if
        index: -1
      }
      {
        name: otp_en_csrng_sw_app_read
        struct: mubi8
        package: prim_mubi_pkg
        type: uni
        act: rcv
        width: 1
        default: prim_mubi_pkg::MuBi8True
        inst_name: csrng
        top_signame: csrng_otp_en_csrng_sw_app_read
        index: -1
      }
      {
        name: lc_hw_debug_en
        struct: lc_tx
        package: lc_ctrl_pkg
        type: uni
        act: rcv
        width: 1
        default: lc_ctrl_pkg::Off
        inst_name: csrng
        domain: Main
        top_signame: lc_ctrl_lc_hw_debug_en
        index: -1
      }
      {
        name: tl
        struct: tl
        package: tlul_pkg
        type: req_rsp
        act: rsp
        width: 1
        inst_name: csrng
        default: ""
        end_idx: -1
        top_type: one-to-one
        top_signame: csrng_tl
        index: -1
      }
      {
        name: entropy_src_hw_if
        struct: entropy_src_hw_if
        package: entropy_src_pkg
        type: req_rsp
        act: rsp
        width: 1
        inst_name: entropy_src
        default: ""
        domain: Main
        top_signame: csrng_entropy_src_hw_if
        index: -1
      }
      {
        name: entropy_src_rng_enable
        desc:
          '''
          Signal through which entropy_src enables the noise source.
          entropy_src will keep this signal high as long as it expects the noise source to operate.
          This is *not* a flow control signal through which entropy_src would exert backpressure on the noise source; rather this signal stays high while entropy_src is enabled.
          '''
        struct: logic
        type: uni
        act: req
        width: 1
        inst_name: entropy_src
        default: ""
        package: ""
        external: true
        conn_type: false
        index: -1
        top_signame: es_rng_enable
      }
      {
        name: entropy_src_rng_valid
        desc:
          '''
          Acknowledgement signal from the noise source.
          When '1', it indicates that the `entropy_src_rng_bit` data is valid and ready to be consumed.
          '''
        struct: logic
        type: uni
        act: rcv
        width: 1
        inst_name: entropy_src
        default: ""
        package: ""
        external: true
        conn_type: false
        index: -1
        top_signame: es_rng_valid
      }
      {
        name: entropy_src_rng_bits
        desc:
          '''
          Output data bus carrying the raw entropy bits from the noise source.
          These bits are valid when `entropy_src_rng_valid` is asserted.
          The width is determined by `RngBusWidth` parametrization.
          '''
        struct: logic
        type: uni
        act: rcv
        width:
        {
          name: RngBusWidth
          desc:
            '''
            Defines the bit-width of the noise source data.
            Must be between 4 and 256 (inclusive) and divisible by 4.
            The divisibility by 4 is a prerequisite for the bucket health test.
            '''
          param_type: int
          unpacked_dimensions: null
          default: 4
          local: false
          expose: true
          name_top: EntropySrcRngBusWidth
        }
        inst_name: entropy_src
        default: ""
        package: ""
        external: true
        conn_type: false
        index: -1
        top_signame: es_rng_bit
      }
      {
        name: entropy_src_xht_valid
        desc:
          '''
          Valid signal for the external health test interface.
          When asserted, it indicates that `entropy_src_xht_bits`, `entropy_src_xht_bit_sel`, and `entropy_src_xht_meta` are valid for consumption by the external health test.
          '''
        struct: logic
        type: uni
        act: req
        width: 1
        inst_name: entropy_src
        index: -1
      }
      {
        name: entropy_src_xht_bits
        desc:
          '''
          Carries the raw entropy data from the entropy source to be consumed by the external health test module.
          The data on this bus is valid when `entropy_src_xht_valid` is asserted.
          The width is determined by `RngBusWidth` parametrization.
          '''
        struct: logic
        type: uni
        act: req
        width:
        {
          name: RngBusWidth
          desc:
            '''
            Defines the bit-width of the noise source data.
            Must be between 4 and 256 (inclusive) and divisible by 4.
            The divisibility by 4 is a prerequisite for the bucket health test.
            '''
          param_type: int
          unpacked_dimensions: null
          default: 4
          local: false
          expose: true
          name_top: EntropySrcRngBusWidth
        }
        inst_name: entropy_src
        index: -1
      }
      {
        name: entropy_src_xht_bit_sel
        desc:
          '''
          Provides bit selection information for the raw entropy data.
          It specifies which specific bit or subset of bits from `entropy_src_xht_bit` should be used.
          The width is determined by `RngBusBitSelWidth` parametrization.
          '''
        struct: logic
        type: uni
        act: req
        width:
        {
          name: RngBusBitSelWidth
          desc: Explicit parameter defining the width of the RNG bit selection vector (log2(RngBusWidth))
          param_type: int
          unpacked_dimensions: null
          default: 2
          local: false
          expose: true
          name_top: EntropySrcRngBusBitSelWidth
        }
        inst_name: entropy_src
        index: -1
      }
      {
        name: entropy_src_xht_health_test_window
        desc: Provides the window size of the health in bits.
        struct: logic
        type: uni
        act: req
        width:
        {
          name: HealthTestWindowWidth
          desc: Explicit parameter defining the width of the health test window (16 + log2(RngBusWidth))
          param_type: int
          unpacked_dimensions: null
          default: 18
          local: false
          expose: true
          name_top: EntropySrcHealthTestWindowWidth
        }
        inst_name: entropy_src
        index: -1
      }
      {
        name: entropy_src_xht_meta
        struct: entropy_src_xht_meta
        package: entropy_src_pkg
        type: req_rsp
        act: req
        width: 1
        inst_name: entropy_src
        index: -1
      }
      {
        name: otp_en_entropy_src_fw_read
        struct: mubi8
        package: prim_mubi_pkg
        type: uni
        act: rcv
        width: 1
        default: prim_mubi_pkg::MuBi8True
        inst_name: entropy_src
        index: -1
      }
      {
        name: otp_en_entropy_src_fw_over
        struct: mubi8
        package: prim_mubi_pkg
        type: uni
        act: rcv
        width: 1
        default: prim_mubi_pkg::MuBi8True
        inst_name: entropy_src
        index: -1
      }
      {
        name: rng_fips
        struct: logic
        type: uni
        act: req
        width: 1
        inst_name: entropy_src
        default: ""
        package: ""
        external: true
        conn_type: false
        index: -1
        top_signame: es_rng_fips
      }
      {
        name: tl
        struct: tl
        package: tlul_pkg
        type: req_rsp
        act: rsp
        width: 1
        inst_name: entropy_src
        default: ""
        end_idx: -1
        top_type: one-to-one
        top_signame: entropy_src_tl
        index: -1
      }
      {
        name: csrng_cmd
        desc: EDN supports a single CSRNG application interface.
        struct: csrng
        package: csrng_pkg
        type: req_rsp
        act: req
        width: 1
        inst_name: edn0
        default: ""
        domain: Main
        top_signame: csrng_csrng_cmd
        index: 0
      }
      {
        name: edn
        desc: Every endpoint has its own peripheral port.
        struct: edn
        package: edn_pkg
        type: req_rsp
        act: rsp
        width:
        {
          name: NumEndPoints
          desc: Number of endpoints
          param_type: int unsigned
          unpacked_dimensions: null
          default: 8
          local: true
          expose: true
          name_top: Edn0NumEndPoints
        }
        default: "'0"
        inst_name: edn0
        end_idx: 7
        top_type: partial-one-to-N
        top_signame: edn0_edn
        index: 3
        external: true
        conn_type: true
      }
      {
        name: tl
        struct: tl
        package: tlul_pkg
        type: req_rsp
        act: rsp
        width: 1
        inst_name: edn0
        default: ""
        end_idx: -1
        top_type: one-to-one
        top_signame: edn0_tl
        index: -1
      }
      {
        name: csrng_cmd
        desc: EDN supports a single CSRNG application interface.
        struct: csrng
        package: csrng_pkg
        type: req_rsp
        act: req
        width: 1
        inst_name: edn1
        default: ""
        domain: Main
        top_signame: csrng_csrng_cmd
        index: 1
      }
      {
        name: edn
        desc: Every endpoint has its own peripheral port.
        struct: edn
        package: edn_pkg
        type: req_rsp
        act: rsp
        width:
        {
          name: NumEndPoints
          desc: Number of endpoints
          param_type: int unsigned
          unpacked_dimensions: null
          default: 8
          local: true
          expose: true
          name_top: Edn1NumEndPoints
        }
        default: "'0"
        inst_name: edn1
        end_idx: -1
        top_type: one-to-one
        top_signame: edn1_edn
        index: -1
      }
      {
        name: tl
        struct: tl
        package: tlul_pkg
        type: req_rsp
        act: rsp
        width: 1
        inst_name: edn1
        default: ""
        end_idx: -1
        top_type: one-to-one
        top_signame: edn1_tl
        index: -1
      }
      {
        name: sram_otp_key
        struct: sram_otp_key
        package: otp_ctrl_pkg
        type: req_rsp
        act: req
        width: 1
        inst_name: sram_ctrl_main
        default: ""
        domain: Main
        top_signame: otp_ctrl_sram_otp_key
        index: 0
      }
      {
        name: ram_cfg
        struct: ram_1p_cfg
        package: prim_ram_1p_pkg
        type: req_rsp
        act: rsp
        width:
        {
          name: NumRamInst
          desc: Number of internal RAM instances. Must be the same as ceil(MemSizeRam / InstSize) .
          param_type: int
          unpacked_dimensions: null
          default: 1
          local: false
          expose: true
          name_top: SramCtrlMainNumRamInst
        }
        inst_name: sram_ctrl_main
        index: -1
      }
      {
        name: lc_escalate_en
        struct: lc_tx
        package: lc_ctrl_pkg
        type: uni
        act: rcv
        width: 1
        default: lc_ctrl_pkg::Off
        inst_name: sram_ctrl_main
        domain: Main
        top_signame: lc_ctrl_lc_escalate_en
        index: -1
      }
      {
        name: lc_hw_debug_en
        struct: lc_tx
        package: lc_ctrl_pkg
        type: uni
        act: rcv
        width: 1
        default: lc_ctrl_pkg::Off
        inst_name: sram_ctrl_main
        domain: Main
        top_signame: lc_ctrl_lc_hw_debug_en
        index: -1
      }
      {
        name: otp_en_sram_ifetch
        struct: mubi8
        package: prim_mubi_pkg
        type: uni
        act: rcv
        width: 1
        default: prim_mubi_pkg::MuBi8False
        inst_name: sram_ctrl_main
        top_signame: sram_ctrl_main_otp_en_sram_ifetch
        index: -1
      }
      {
        name: racl_policies
        desc:
          '''
          Incoming RACL policy vector from a racl_ctrl instance.
          The policy selection vector (parameter) selects the policy for each register.
          '''
        struct: racl_policy_vec
        package: top_racl_pkg
        type: uni
        act: rcv
        width: 1
        inst_name: sram_ctrl_main
        index: -1
      }
      {
        name: racl_error
        desc: RACL error log information of this module.
        struct: racl_error_log
        package: top_racl_pkg
        type: uni
        act: req
        width: 1
        inst_name: sram_ctrl_main
        index: -1
      }
      {
        name: sram_rerror
        desc: SRAM read error indicating correctable and uncorrectable ECC errors.
        struct: sram_error_t
        package: sram_ctrl_pkg
        type: uni
        act: req
        width: 1
        inst_name: sram_ctrl_main
        index: -1
      }
      {
        name: regs_tl
        struct: tl
        package: tlul_pkg
        type: req_rsp
        act: rsp
        width: 1
        inst_name: sram_ctrl_main
        default: ""
        end_idx: -1
        top_type: one-to-one
        top_signame: sram_ctrl_main_regs_tl
        index: -1
      }
      {
        name: ram_tl
        struct: tl
        package: tlul_pkg
        type: req_rsp
        act: rsp
        width: 1
        inst_name: sram_ctrl_main
        default: ""
        end_idx: -1
        top_type: one-to-one
        top_signame: sram_ctrl_main_ram_tl
        index: -1
      }
      {
        name: rom_cfg
        struct: rom_cfg
        package: prim_rom_pkg
        type: req_rsp
        act: rsp
        width: 1
        inst_name: rom_ctrl
        index: -1
      }
      {
        name: pwrmgr_data
        struct: pwrmgr_data
        package: rom_ctrl_pkg
        type: uni
        act: req
        width: 1
        inst_name: rom_ctrl
        default: ""
        domain: Main
        top_signame: pwrmgr_rom_ctrl
        index: -1
        external: true
        conn_type: false
      }
      {
        name: keymgr_data
        struct: keymgr_data
        package: rom_ctrl_pkg
        type: uni
        act: req
        width: 1
        inst_name: rom_ctrl
        default: ""
        domain: Main
        top_signame: keymgr_dpe_rom_digest
        index: -1
      }
      {
        name: kmac_data
        struct: app
        package: kmac_pkg
        type: req_rsp
        act: req
        width: 1
        inst_name: rom_ctrl
        default: ""
        domain: Main
        top_signame: kmac_app
        index: 2
      }
      {
        name: regs_tl
        struct: tl
        package: tlul_pkg
        type: req_rsp
        act: rsp
        width: 1
        inst_name: rom_ctrl
        default: ""
        end_idx: -1
        top_type: one-to-one
        top_signame: rom_ctrl_regs_tl
        index: -1
      }
      {
        name: rom_tl
        struct: tl
        package: tlul_pkg
        type: req_rsp
        act: rsp
        width: 1
        inst_name: rom_ctrl
        default: ""
        end_idx: -1
        top_type: one-to-one
        top_signame: rom_ctrl_rom_tl
        index: -1
      }
      {
        name: lsio_trigger
        struct: lsio_trigger
        package: dma_pkg
        type: uni
        act: rcv
        width: 1
        inst_name: dma
        default: ""
        end_idx: -1
        top_type: broadcast
        index: -1
      }
      {
        name: sys
        desc: SoC System Bus (requests and responses), synchronous
        struct: sys
        package: dma_pkg
        type: req_rsp
        act: req
        width: 1
        default: dma_pkg::SYS_RSP_DEFAULT
        inst_name: dma
        end_idx: -1
        top_type: broadcast
        index: -1
      }
      {
        name: ctn_tl_h2d
        desc: TL-UL host port for egress into CTN (request part), synchronous
        struct: tl_h2d
        package: tlul_pkg
        type: uni
        act: req
        width: 1
        inst_name: dma
        index: -1
      }
      {
        name: ctn_tl_d2h
        desc: TL-UL host port for egress into CTN (response part), synchronous
        struct: tl_d2h
        package: tlul_pkg
        type: uni
        act: rcv
        width: 1
        inst_name: dma
        index: -1
      }
      {
        name: racl_policies
        desc:
          '''
          Incoming RACL policy vector from a racl_ctrl instance.
          The policy selection vector (parameter) selects the policy for each register.
          '''
        struct: racl_policy_vec
        package: top_racl_pkg
        type: uni
        act: rcv
        width: 1
        inst_name: dma
        index: -1
      }
      {
        name: racl_error
        desc: RACL error log information of this module.
        struct: racl_error_log
        package: top_racl_pkg
        type: uni
        act: req
        width: 1
        inst_name: dma
        index: -1
      }
      {
        name: host_tl_h
        struct: tl
        package: tlul_pkg
        type: req_rsp
        act: req
        width: 1
        inst_name: dma
        default: ""
        domain: Main
        top_signame: main_tl_dma__host
        index: -1
      }
      {
        name: tl_d
        struct: tl
        package: tlul_pkg
        type: req_rsp
        act: rsp
        width: 1
        inst_name: dma
        default: ""
        end_idx: -1
        top_type: one-to-one
        top_signame: dma_tl_d
        index: -1
      }
      {
        name: ahb_sub_m2s
        desc: AHB subordinate request in (external SoC AHB manager)
        struct: ahb_m2s
        package: ahb_pkg
        type: uni
        act: rcv
        width: 1
        inst_name: ahb_bridge
        default: ""
        external: true
        conn_type: false
        index: -1
        top_signame: soc_mbx_ahb_req
      }
      {
        name: ahb_sub_s2m
        desc: AHB subordinate response out
        struct: ahb_s2m
        package: ahb_pkg
        type: uni
        act: req
        width: 1
        inst_name: ahb_bridge
        default: ""
        external: true
        conn_type: false
        index: -1
        top_signame: soc_mbx_ahb_rsp
      }
      {
        name: ahb_mgr_m2s
        desc: AHB manager request out (to external SoC AHB subordinate)
        struct: ahb_m2s
        package: ahb_pkg
        type: uni
        act: req
        width: 1
        inst_name: ahb_bridge
        default: ""
        external: true
        conn_type: false
        index: -1
        top_signame: soc_mgr_ahb_req
      }
      {
        name: ahb_mgr_s2m
        desc: AHB manager response in
        struct: ahb_s2m
        package: ahb_pkg
        type: uni
        act: rcv
        width: 1
        inst_name: ahb_bridge
        default: ""
        external: true
        conn_type: false
        index: -1
        top_signame: soc_mgr_ahb_rsp
      }
      {
        name: socmbx_tl_h
        struct: tl
        package: tlul_pkg
        type: req_rsp
        act: req
        width: 1
        inst_name: ahb_bridge
        default: ""
        domain: Main
        top_signame: socmbx_tl_ahb_bridge__socmbx
        index: -1
      }
      {
        name: ctn_tl_d
        struct: tl
        package: tlul_pkg
        type: req_rsp
        act: rsp
        width: 1
        inst_name: ahb_bridge
        default: ""
        end_idx: -1
        top_type: one-to-one
        top_signame: ahb_bridge_ctn_tl_d
        index: -1
      }
      {
        name: doe_intr_support
        struct: logic
        type: uni
        act: req
        width: 1
        default: 1'b0
        inst_name: mbx0
        package: ""
        external: true
        conn_type: false
        index: -1
        top_signame: mbx0_doe_intr_support
      }
      {
        name: doe_intr_en
        struct: logic
        type: uni
        act: req
        width: 1
        default: 1'b0
        inst_name: mbx0
        package: ""
        external: true
        conn_type: false
        index: -1
        top_signame: mbx0_doe_intr_en
      }
      {
        name: doe_intr
        struct: logic
        type: uni
        act: req
        width: 1
        default: 1'b0
        inst_name: mbx0
        package: ""
        external: true
        conn_type: false
        index: -1
        top_signame: mbx0_doe_intr
      }
      {
        name: doe_async_msg_support
        struct: logic
        type: uni
        act: req
        width: 1
        default: 1'b0
        inst_name: mbx0
        package: ""
        external: true
        conn_type: false
        index: -1
        top_signame: mbx0_doe_async_msg_support
      }
      {
        name: racl_policies
        desc:
          '''
          Incoming RACL policy vector from a racl_ctrl instance.
          The policy selection vector (parameter) selects the policy for each register.
          '''
        struct: racl_policy_vec
        package: top_racl_pkg
        type: uni
        act: rcv
        width: 1
        inst_name: mbx0
        index: -1
      }
      {
        name: racl_error
        desc: RACL error log information of this module.
        struct: racl_error_log
        package: top_racl_pkg
        type: uni
        act: req
        width: 1
        inst_name: mbx0
        index: -1
      }
      {
        name: sram_tl_h
        struct: tl
        package: tlul_pkg
        type: req_rsp
        act: req
        width: 1
        inst_name: mbx0
        default: ""
        domain: Main
        top_signame: main_tl_mbx0__sram
        index: -1
      }
      {
        name: core_tl_d
        struct: tl
        package: tlul_pkg
        type: req_rsp
        act: rsp
        width: 1
        inst_name: mbx0
        default: ""
        end_idx: -1
        top_type: one-to-one
        top_signame: mbx0_core_tl_d
        index: -1
      }
      {
        name: soc_tl_d
        struct: tl
        package: tlul_pkg
        type: req_rsp
        act: rsp
        width: 1
        inst_name: mbx0
        default: ""
        end_idx: -1
        top_type: one-to-one
        top_signame: mbx0_soc_tl_d
        index: -1
      }
      {
        name: doe_intr_support
        struct: logic
        type: uni
        act: req
        width: 1
        default: 1'b0
        inst_name: mbx1
        package: ""
        external: true
        conn_type: false
        index: -1
        top_signame: mbx1_doe_intr_support
      }
      {
        name: doe_intr_en
        struct: logic
        type: uni
        act: req
        width: 1
        default: 1'b0
        inst_name: mbx1
        package: ""
        external: true
        conn_type: false
        index: -1
        top_signame: mbx1_doe_intr_en
      }
      {
        name: doe_intr
        struct: logic
        type: uni
        act: req
        width: 1
        default: 1'b0
        inst_name: mbx1
        package: ""
        external: true
        conn_type: false
        index: -1
        top_signame: mbx1_doe_intr
      }
      {
        name: doe_async_msg_support
        struct: logic
        type: uni
        act: req
        width: 1
        default: 1'b0
        inst_name: mbx1
        package: ""
        external: true
        conn_type: false
        index: -1
        top_signame: mbx1_doe_async_msg_support
      }
      {
        name: racl_policies
        desc:
          '''
          Incoming RACL policy vector from a racl_ctrl instance.
          The policy selection vector (parameter) selects the policy for each register.
          '''
        struct: racl_policy_vec
        package: top_racl_pkg
        type: uni
        act: rcv
        width: 1
        inst_name: mbx1
        index: -1
      }
      {
        name: racl_error
        desc: RACL error log information of this module.
        struct: racl_error_log
        package: top_racl_pkg
        type: uni
        act: req
        width: 1
        inst_name: mbx1
        index: -1
      }
      {
        name: sram_tl_h
        struct: tl
        package: tlul_pkg
        type: req_rsp
        act: req
        width: 1
        inst_name: mbx1
        default: ""
        domain: Main
        top_signame: main_tl_mbx1__sram
        index: -1
      }
      {
        name: core_tl_d
        struct: tl
        package: tlul_pkg
        type: req_rsp
        act: rsp
        width: 1
        inst_name: mbx1
        default: ""
        end_idx: -1
        top_type: one-to-one
        top_signame: mbx1_core_tl_d
        index: -1
      }
      {
        name: soc_tl_d
        struct: tl
        package: tlul_pkg
        type: req_rsp
        act: rsp
        width: 1
        inst_name: mbx1
        default: ""
        end_idx: -1
        top_type: one-to-one
        top_signame: mbx1_soc_tl_d
        index: -1
      }
      {
        name: rst_cpu_n
        struct: logic
        type: uni
        act: req
        width: 1
        inst_name: rv_core_ibex
        index: -1
      }
      {
        name: ram_cfg_icache_tag
        struct: ram_1p_cfg
        package: prim_ram_1p_pkg
        type: req_rsp
        act: rsp
        width:
        {
          name: ICacheNWays
          desc: Number of instruction cache ways
          param_type: int unsigned
          unpacked_dimensions: null
          default: 2
          local: false
          expose: true
          name_top: RvCoreIbexICacheNWays
        }
        inst_name: rv_core_ibex
        index: -1
      }
      {
        name: ram_cfg_icache_data
        struct: ram_1p_cfg
        package: prim_ram_1p_pkg
        type: req_rsp
        act: rsp
        width:
        {
          name: ICacheNWays
          desc: Number of instruction cache ways
          param_type: int unsigned
          unpacked_dimensions: null
          default: 2
          local: false
          expose: true
          name_top: RvCoreIbexICacheNWays
        }
        inst_name: rv_core_ibex
        index: -1
      }
      {
        name: hart_id
        struct: logic
        type: uni
        act: rcv
        width: 32
        inst_name: rv_core_ibex
        default: ""
        package: ""
        top_signame: rv_core_ibex_hart_id
        index: -1
      }
      {
        name: boot_addr
        struct: logic
        type: uni
        act: rcv
        width: 32
        inst_name: rv_core_ibex
        default: ""
        package: ""
        top_signame: rv_core_ibex_boot_addr
        index: -1
      }
      {
        name: irq_software
        struct: logic
        type: uni
        act: rcv
        width: 1
        inst_name: rv_core_ibex
        default: ""
        package: ""
        domain: Main
        top_signame: rv_plic_msip
        index: -1
      }
      {
        name: irq_timer
        struct: logic
        type: uni
        act: rcv
        width: 1
        inst_name: rv_core_ibex
        default: ""
        package: ""
        top_signame: rv_core_ibex_irq_timer
        index: -1
      }
      {
        name: irq_external
        struct: logic
        type: uni
        act: rcv
        width: 1
        inst_name: rv_core_ibex
        default: ""
        package: ""
        domain: Main
        top_signame: rv_plic_irq
        index: -1
      }
      {
        name: esc_tx
        struct: esc_tx
        package: prim_esc_pkg
        type: uni
        act: rcv
        width: 1
        inst_name: rv_core_ibex
        default: ""
        domain: Main
        top_signame: alert_handler_esc_tx
        index: 0
        external: true
        conn_type: false
      }
      {
        name: esc_rx
        struct: esc_rx
        package: prim_esc_pkg
        type: uni
        act: req
        width: 1
        inst_name: rv_core_ibex
        default: ""
        domain: Main
        top_signame: alert_handler_esc_rx
        index: 0
        external: true
        conn_type: false
      }
      {
        name: debug_req
        struct: logic
        type: uni
        act: rcv
        width: 1
        inst_name: rv_core_ibex
        default: ""
        package: ""
        domain: Main
        top_signame: rv_dm_debug_req
        index: -1
      }
      {
        name: crash_dump
        struct: cpu_crash_dump
        package: rv_core_ibex_pkg
        type: uni
        act: req
        width: 1
        inst_name: rv_core_ibex
        default: ""
        end_idx: -1
        top_type: broadcast
        top_signame: rv_core_ibex_crash_dump
        index: -1
        external: true
        conn_type: false
      }
      {
        name: lc_cpu_en
        struct: lc_tx
        package: lc_ctrl_pkg
        type: uni
        act: rcv
        width: 1
        default: lc_ctrl_pkg::On
        inst_name: rv_core_ibex
        domain: Main
        top_signame: lc_ctrl_lc_cpu_en
        index: -1
      }
      {
        name: pwrmgr_cpu_en
        struct: lc_tx
        package: lc_ctrl_pkg
        type: uni
        act: rcv
        width: 1
        inst_name: rv_core_ibex
        default: ""
        domain: Main
        top_signame: pwrmgr_fetch_en
        index: -1
        external: true
        conn_type: false
      }
      {
        name: pwrmgr
        struct: cpu_pwrmgr
        package: rv_core_ibex_pkg
        type: uni
        act: req
        width: 1
        inst_name: rv_core_ibex
        default: ""
        end_idx: -1
        top_type: broadcast
        top_signame: rv_core_ibex_pwrmgr
        index: -1
        external: true
        conn_type: false
      }
      {
        name: nmi_wdog
        struct: logic
        type: uni
        act: rcv
        width: 1
        inst_name: rv_core_ibex
        index: -1
      }
      {
        name: edn
        struct: edn
        package: edn_pkg
        type: req_rsp
        act: req
        width: 1
        inst_name: rv_core_ibex
        default: ""
        domain: Main
        top_signame: edn0_edn
        index: 6
      }
      {
        name: icache_otp_key
        struct: sram_otp_key
        package: otp_ctrl_pkg
        type: req_rsp
        act: req
        width: 1
        inst_name: rv_core_ibex
        default: ""
        domain: Main
        top_signame: otp_ctrl_sram_otp_key
        index: 2
      }
      {
        name: fpga_info
        struct: logic
        type: uni
        act: rcv
        width: 32
        inst_name: rv_core_ibex
        index: -1
      }
      {
        name: corei_tl_h
        struct: tl
        package: tlul_pkg
        type: req_rsp
        act: req
        width: 1
        inst_name: rv_core_ibex
        default: ""
        domain: Main
        top_signame: main_tl_rv_core_ibex__corei
        index: -1
      }
      {
        name: cored_tl_h
        struct: tl
        package: tlul_pkg
        type: req_rsp
        act: req
        width: 1
        inst_name: rv_core_ibex
        default: ""
        domain: Main
        top_signame: main_tl_rv_core_ibex__cored
        index: -1
      }
      {
        name: cfg_tl_d
        struct: tl
        package: tlul_pkg
        type: req_rsp
        act: rsp
        width: 1
        inst_name: rv_core_ibex
        default: ""
        end_idx: -1
        top_type: one-to-one
        top_signame: rv_core_ibex_cfg_tl_d
        index: -1
      }
      {
        name: tl_rv_core_ibex__corei
        struct: tl
        package: tlul_pkg
        type: req_rsp
        act: rsp
        inst_name: main
        width: 1
        default: ""
        end_idx: -1
        top_type: one-to-one
        top_signame: main_tl_rv_core_ibex__corei
        index: -1
      }
      {
        name: tl_rv_core_ibex__cored
        struct: tl
        package: tlul_pkg
        type: req_rsp
        act: rsp
        inst_name: main
        width: 1
        default: ""
        end_idx: -1
        top_type: one-to-one
        top_signame: main_tl_rv_core_ibex__cored
        index: -1
      }
      {
        name: tl_rv_dm__sba
        struct: tl
        package: tlul_pkg
        type: req_rsp
        act: rsp
        inst_name: main
        width: 1
        default: ""
        end_idx: -1
        top_type: one-to-one
        top_signame: main_tl_rv_dm__sba
        index: -1
      }
      {
        name: tl_dma__host
        struct: tl
        package: tlul_pkg
        type: req_rsp
        act: rsp
        inst_name: main
        width: 1
        default: ""
        end_idx: -1
        top_type: one-to-one
        top_signame: main_tl_dma__host
        index: -1
      }
      {
        name: tl_mbx0__sram
        struct: tl
        package: tlul_pkg
        type: req_rsp
        act: rsp
        inst_name: main
        width: 1
        default: ""
        end_idx: -1
        top_type: one-to-one
        top_signame: main_tl_mbx0__sram
        index: -1
      }
      {
        name: tl_mbx1__sram
        struct: tl
        package: tlul_pkg
        type: req_rsp
        act: rsp
        inst_name: main
        width: 1
        default: ""
        end_idx: -1
        top_type: one-to-one
        top_signame: main_tl_mbx1__sram
        index: -1
      }
      {
        name: tl_rv_dm__regs
        struct: tl
        package: tlul_pkg
        type: req_rsp
        act: req
        inst_name: main
        width: 1
        default: ""
        domain: Main
        top_signame: rv_dm_regs_tl_d
        index: -1
      }
      {
        name: tl_rv_dm__mem
        struct: tl
        package: tlul_pkg
        type: req_rsp
        act: req
        inst_name: main
        width: 1
        default: ""
        domain: Main
        top_signame: rv_dm_mem_tl_d
        index: -1
      }
      {
        name: tl_rom_ctrl__rom
        struct: tl
        package: tlul_pkg
        type: req_rsp
        act: req
        inst_name: main
        width: 1
        default: ""
        domain: Main
        top_signame: rom_ctrl_rom_tl
        index: -1
      }
      {
        name: tl_rom_ctrl__regs
        struct: tl
        package: tlul_pkg
        type: req_rsp
        act: req
        inst_name: main
        width: 1
        default: ""
        domain: Main
        top_signame: rom_ctrl_regs_tl
        index: -1
      }
      {
        name: tl_sram_ctrl_main__regs
        struct: tl
        package: tlul_pkg
        type: req_rsp
        act: req
        inst_name: main
        width: 1
        default: ""
        domain: Main
        top_signame: sram_ctrl_main_regs_tl
        index: -1
      }
      {
        name: tl_sram_ctrl_main__ram
        struct: tl
        package: tlul_pkg
        type: req_rsp
        act: req
        inst_name: main
        width: 1
        default: ""
        domain: Main
        top_signame: sram_ctrl_main_ram_tl
        index: -1
      }
      {
        name: tl_otp_ctrl__core
        struct: tl
        package: tlul_pkg
        type: req_rsp
        act: req
        inst_name: main
        width: 1
        default: ""
        domain: Main
        top_signame: otp_ctrl_core_tl
        index: -1
      }
      {
        name: tl_otp_macro__prim
        struct: tl
        package: tlul_pkg
        type: req_rsp
        act: req
        inst_name: main
        width: 1
        default: ""
        domain: Main
        top_signame: otp_macro_prim_tl
        index: -1
      }
      {
        name: tl_lc_ctrl__regs
        struct: tl
        package: tlul_pkg
        type: req_rsp
        act: req
        inst_name: main
        width: 1
        default: ""
        domain: Main
        top_signame: lc_ctrl_regs_tl
        index: -1
      }
      {
        name: tl_rv_plic
        struct: tl
        package: tlul_pkg
        type: req_rsp
        act: req
        inst_name: main
        width: 1
        default: ""
        domain: Main
        top_signame: rv_plic_tl
        index: -1
      }
      {
        name: tl_rv_timer
        struct: tl
        package: tlul_pkg
        type: req_rsp
        act: req
        inst_name: main
        width: 1
        default: ""
        domain: Main
        top_signame: rv_timer_tl
        index: -1
      }
      {
        name: tl_aes
        struct: tl
        package: tlul_pkg
        type: req_rsp
        act: req
        inst_name: main
        width: 1
        default: ""
        domain: Main
        top_signame: aes_tl
        index: -1
      }
      {
        name: tl_hmac
        struct: tl
        package: tlul_pkg
        type: req_rsp
        act: req
        inst_name: main
        width: 1
        default: ""
        domain: Main
        top_signame: hmac_tl
        index: -1
      }
      {
        name: tl_kmac
        struct: tl
        package: tlul_pkg
        type: req_rsp
        act: req
        inst_name: main
        width: 1
        default: ""
        domain: Main
        top_signame: kmac_tl
        index: -1
      }
      {
        name: tl_otbn
        struct: tl
        package: tlul_pkg
        type: req_rsp
        act: req
        inst_name: main
        width: 1
        default: ""
        domain: Main
        top_signame: otbn_tl
        index: -1
      }
      {
        name: tl_keymgr_dpe
        struct: tl
        package: tlul_pkg
        type: req_rsp
        act: req
        inst_name: main
        width: 1
        default: ""
        domain: Main
        top_signame: keymgr_dpe_tl
        index: -1
      }
      {
        name: tl_csrng
        struct: tl
        package: tlul_pkg
        type: req_rsp
        act: req
        inst_name: main
        width: 1
        default: ""
        domain: Main
        top_signame: csrng_tl
        index: -1
      }
      {
        name: tl_entropy_src
        struct: tl
        package: tlul_pkg
        type: req_rsp
        act: req
        inst_name: main
        width: 1
        default: ""
        domain: Main
        top_signame: entropy_src_tl
        index: -1
      }
      {
        name: tl_edn0
        struct: tl
        package: tlul_pkg
        type: req_rsp
        act: req
        inst_name: main
        width: 1
        default: ""
        domain: Main
        top_signame: edn0_tl
        index: -1
      }
      {
        name: tl_edn1
        struct: tl
        package: tlul_pkg
        type: req_rsp
        act: req
        inst_name: main
        width: 1
        default: ""
        domain: Main
        top_signame: edn1_tl
        index: -1
      }
      {
        name: tl_rv_core_ibex__cfg
        struct: tl
        package: tlul_pkg
        type: req_rsp
        act: req
        inst_name: main
        width: 1
        default: ""
        domain: Main
        top_signame: rv_core_ibex_cfg_tl_d
        index: -1
      }
      {
        name: tl_dma
        struct: tl
        package: tlul_pkg
        type: req_rsp
        act: req
        inst_name: main
        width: 1
        default: ""
        domain: Main
        top_signame: dma_tl_d
        index: -1
      }
      {
        name: tl_ahb_bridge__ctn
        struct: tl
        package: tlul_pkg
        type: req_rsp
        act: req
        inst_name: main
        width: 1
        default: ""
        domain: Main
        top_signame: ahb_bridge_ctn_tl_d
        index: -1
      }
      {
        name: tl_mbx0__core
        struct: tl
        package: tlul_pkg
        type: req_rsp
        act: req
        inst_name: main
        width: 1
        default: ""
        domain: Main
        top_signame: mbx0_core_tl_d
        index: -1
      }
      {
        name: tl_mbx1__core
        struct: tl
        package: tlul_pkg
        type: req_rsp
        act: req
        inst_name: main
        width: 1
        default: ""
        domain: Main
        top_signame: mbx1_core_tl_d
        index: -1
      }
      {
        name: tl_aon
        struct: tl
        package: tlul_pkg
        type: req_rsp
        act: req
        inst_name: main
        width: 1
        default: ""
        end_idx: -1
        top_type: one-to-one
        top_signame: main_tl_aon
        index: -1
        external: true
        conn_type: false
      }
      {
        name: tl_main
        struct: tl
        package: tlul_pkg
        type: req_rsp
        act: rsp
        inst_name: aon
        width: 1
        default: ""
        domain: Aon
        top_signame: main_tl_aon
        index: -1
        external: true
        conn_type: false
      }
      {
        name: tl_pwrmgr
        struct: tl
        package: tlul_pkg
        type: req_rsp
        act: req
        inst_name: aon
        width: 1
        default: ""
        domain: Aon
        top_signame: pwrmgr_tl
        index: -1
      }
      {
        name: tl_rstmgr
        struct: tl
        package: tlul_pkg
        type: req_rsp
        act: req
        inst_name: aon
        width: 1
        default: ""
        domain: Aon
        top_signame: rstmgr_tl
        index: -1
      }
      {
        name: tl_clkmgr
        struct: tl
        package: tlul_pkg
        type: req_rsp
        act: req
        inst_name: aon
        width: 1
        default: ""
        domain: Aon
        top_signame: clkmgr_tl
        index: -1
      }
      {
        name: tl_alert_handler
        struct: tl
        package: tlul_pkg
        type: req_rsp
        act: req
        inst_name: aon
        width: 1
        default: ""
        domain: Aon
        top_signame: alert_handler_tl
        index: -1
      }
      {
        name: tl_rv_timer_aon
        struct: tl
        package: tlul_pkg
        type: req_rsp
        act: req
        inst_name: aon
        width: 1
        default: ""
        domain: Aon
        top_signame: rv_timer_aon_tl
        index: -1
      }
      {
        name: tl_sram_ctrl_ret_aon__regs
        struct: tl
        package: tlul_pkg
        type: req_rsp
        act: req
        inst_name: aon
        width: 1
        default: ""
        domain: Aon
        top_signame: sram_ctrl_ret_aon_regs_tl
        index: -1
      }
      {
        name: tl_sram_ctrl_ret_aon__ram
        struct: tl
        package: tlul_pkg
        type: req_rsp
        act: req
        inst_name: aon
        width: 1
        default: ""
        domain: Aon
        top_signame: sram_ctrl_ret_aon_ram_tl
        index: -1
      }
      {
        name: tl_ahb_bridge__socmbx
        struct: tl
        package: tlul_pkg
        type: req_rsp
        act: rsp
        inst_name: socmbx
        width: 1
        default: ""
        end_idx: -1
        top_type: one-to-one
        top_signame: socmbx_tl_ahb_bridge__socmbx
        index: -1
      }
      {
        name: tl_mbx0__soc
        struct: tl
        package: tlul_pkg
        type: req_rsp
        act: req
        inst_name: socmbx
        width: 1
        default: ""
        domain: Main
        top_signame: mbx0_soc_tl_d
        index: -1
      }
      {
        name: tl_mbx1__soc
        struct: tl
        package: tlul_pkg
        type: req_rsp
        act: req
        inst_name: socmbx
        width: 1
        default: ""
        domain: Main
        top_signame: mbx1_soc_tl_d
        index: -1
      }
      {
        name: tl_ext_socdbg_host
        struct: tl
        package: tlul_pkg
        type: req_rsp
        act: rsp
        inst_name: socdbg
        width: 1
        default: ""
        external: true
        conn_type: false
        index: -1
        top_signame: soc_dbg_tl
      }
      {
        name: tl_lc_ctrl__dmi
        struct: tl
        package: tlul_pkg
        type: req_rsp
        act: req
        inst_name: socdbg
        width: 1
        default: ""
        domain: Main
        top_signame: lc_ctrl_dmi_tl
        index: -1
      }
      {
        name: tl_rv_dm__dbg
        struct: tl
        package: tlul_pkg
        type: req_rsp
        act: req
        inst_name: socdbg
        width: 1
        default: ""
        domain: Main
        top_signame: rv_dm_dbg_tl_d
        index: -1
      }
    ]
    external:
    [
      {
        package: pwrmgr_pkg
        struct: pwr_otp_req
        domain: Aon
        inter_pd: true
        signame: pwrmgr_pwr_otp_req_o
        signame_chip:
        {
          verilator: pwrmgr_pwr_otp_req
        }
        width: 1
        type: req_rsp
        default: ""
        direction: out
        conn_type: false
        index: -1
        netname: pwrmgr_pwr_otp_req
      }
      {
        package: pwrmgr_pkg
        struct: pwr_otp_rsp
        domain: Aon
        inter_pd: true
        signame: pwrmgr_pwr_otp_rsp_i
        signame_chip:
        {
          verilator: pwrmgr_pwr_otp_rsp
        }
        width: 1
        type: req_rsp
        default: ""
        direction: in
        conn_type: false
        index: -1
        netname: pwrmgr_pwr_otp_rsp
      }
      {
        package: pwrmgr_pkg
        struct: pwr_otp_req
        domain: Main
        inter_pd: true
        signame: pwrmgr_pwr_otp_req_i
        signame_chip:
        {
          verilator: pwrmgr_pwr_otp_req
        }
        width: 1
        type: req_rsp
        default: ""
        direction: in
        conn_type: false
        index: -1
        netname: pwrmgr_pwr_otp_req
      }
      {
        package: pwrmgr_pkg
        struct: pwr_otp_rsp
        domain: Main
        inter_pd: true
        signame: pwrmgr_pwr_otp_rsp_o
        signame_chip:
        {
          verilator: pwrmgr_pwr_otp_rsp
        }
        width: 1
        type: req_rsp
        default: ""
        direction: out
        conn_type: false
        index: -1
        netname: pwrmgr_pwr_otp_rsp
      }
      {
        package: lc_ctrl_pkg
        struct: pwr_lc_req
        domain: Aon
        inter_pd: true
        signame: pwrmgr_pwr_lc_req_o
        signame_chip:
        {
          verilator: pwrmgr_pwr_lc_req
        }
        width: 1
        type: req_rsp
        default: ""
        direction: out
        conn_type: false
        index: -1
        netname: pwrmgr_pwr_lc_req
      }
      {
        package: lc_ctrl_pkg
        struct: pwr_lc_rsp
        domain: Aon
        inter_pd: true
        signame: pwrmgr_pwr_lc_rsp_i
        signame_chip:
        {
          verilator: pwrmgr_pwr_lc_rsp
        }
        width: 1
        type: req_rsp
        default: ""
        direction: in
        conn_type: false
        index: -1
        netname: pwrmgr_pwr_lc_rsp
      }
      {
        package: lc_ctrl_pkg
        struct: pwr_lc_req
        domain: Main
        inter_pd: true
        signame: pwrmgr_pwr_lc_req_i
        signame_chip:
        {
          verilator: pwrmgr_pwr_lc_req
        }
        width: 1
        type: req_rsp
        default: ""
        direction: in
        conn_type: false
        index: -1
        netname: pwrmgr_pwr_lc_req
      }
      {
        package: lc_ctrl_pkg
        struct: pwr_lc_rsp
        domain: Main
        inter_pd: true
        signame: pwrmgr_pwr_lc_rsp_o
        signame_chip:
        {
          verilator: pwrmgr_pwr_lc_rsp
        }
        width: 1
        type: req_rsp
        default: ""
        direction: out
        conn_type: false
        index: -1
        netname: pwrmgr_pwr_lc_rsp
      }
      {
        package: ""
        struct: logic
        domain: Aon
        inter_pd: true
        signame: pwrmgr_strap_o
        signame_chip:
        {
          verilator: pwrmgr_strap
        }
        width: 1
        type: uni
        default: ""
        direction: out
        conn_type: false
        index: -1
        netname: pwrmgr_strap
      }
      {
        package: ""
        struct: logic
        domain: Main
        inter_pd: true
        signame: pwrmgr_strap_i
        signame_chip:
        {
          verilator: pwrmgr_strap
        }
        width: 1
        type: uni
        default: ""
        direction: in
        conn_type: false
        index: -1
        netname: pwrmgr_strap
      }
      {
        package: lc_ctrl_pkg
        struct: lc_tx
        domain: Aon
        inter_pd: true
        signame: pwrmgr_fetch_en_o
        signame_chip:
        {
          verilator: pwrmgr_fetch_en
        }
        width: 1
        type: uni
        default: ""
        direction: out
        conn_type: false
        index: -1
        netname: pwrmgr_fetch_en
      }
      {
        package: lc_ctrl_pkg
        struct: lc_tx
        domain: Main
        inter_pd: true
        signame: pwrmgr_fetch_en_i
        signame_chip:
        {
          verilator: pwrmgr_fetch_en
        }
        width: 1
        type: uni
        default: ""
        direction: in
        conn_type: false
        index: -1
        netname: pwrmgr_fetch_en
      }
      {
        package: rom_ctrl_pkg
        struct: pwrmgr_data
        domain: Aon
        inter_pd: true
        signame: pwrmgr_rom_ctrl_i
        signame_chip:
        {
          verilator: pwrmgr_rom_ctrl
        }
        width: 1
        type: uni
        default: rom_ctrl_pkg::PWRMGR_DATA_DEFAULT
        direction: in
        conn_type: false
        index: -1
        netname: pwrmgr_rom_ctrl
      }
      {
        package: rom_ctrl_pkg
        struct: pwrmgr_data
        domain: Main
        inter_pd: true
        signame: pwrmgr_rom_ctrl_o
        signame_chip:
        {
          verilator: pwrmgr_rom_ctrl
        }
        width: 1
        type: uni
        default: rom_ctrl_pkg::PWRMGR_DATA_DEFAULT
        direction: out
        conn_type: false
        index: -1
        netname: pwrmgr_rom_ctrl
      }
      {
        package: prim_esc_pkg
        struct: esc_rx
        domain: Aon
        inter_pd: true
        signame: alert_handler_esc_rx_i
        signame_chip:
        {
          verilator: alert_handler_esc_rx
        }
        width: 3
        type: uni
        default: ""
        direction: in
        conn_type: true
        index:
        [
          0
          1
          2
        ]
        netname: alert_handler_esc_rx
      }
      {
        package: prim_esc_pkg
        struct: esc_rx
        domain: Main
        inter_pd: true
        signame: alert_handler_esc_rx_o
        signame_chip:
        {
          verilator: alert_handler_esc_rx
        }
        width: 3
        type: uni
        default: ""
        direction: out
        conn_type: false
        index:
        [
          0
          1
          2
        ]
        netname: alert_handler_esc_rx
      }
      {
        package: prim_esc_pkg
        struct: esc_tx
        domain: Aon
        inter_pd: true
        signame: alert_handler_esc_tx_o
        signame_chip:
        {
          verilator: alert_handler_esc_tx
        }
        width: 3
        type: uni
        default: ""
        direction: out
        conn_type: true
        index:
        [
          0
          1
          2
        ]
        netname: alert_handler_esc_tx
      }
      {
        package: prim_esc_pkg
        struct: esc_tx
        domain: Main
        inter_pd: true
        signame: alert_handler_esc_tx_i
        signame_chip:
        {
          verilator: alert_handler_esc_tx
        }
        width: 3
        type: uni
        default: ""
        direction: in
        conn_type: false
        index:
        [
          0
          1
          2
        ]
        netname: alert_handler_esc_tx
      }
      {
        package: edn_pkg
        struct: edn_req
        domain: Main
        inter_pd: true
        signame: edn0_edn_req_i
        signame_chip:
        {
          verilator: edn0_edn_req
        }
        width: 1
        type: req_rsp
        default: "'0"
        direction: in
        conn_type: true
        index: 3
        netname: edn0_edn_req
      }
      {
        package: edn_pkg
        struct: edn_rsp
        domain: Main
        inter_pd: true
        signame: edn0_edn_rsp_o
        signame_chip:
        {
          verilator: edn0_edn_rsp
        }
        width: 1
        type: req_rsp
        default: "'0"
        direction: out
        conn_type: true
        index: 3
        netname: edn0_edn_rsp
      }
      {
        package: edn_pkg
        struct: edn_req
        domain: Aon
        inter_pd: true
        signame: edn0_edn_req_o
        signame_chip:
        {
          verilator: edn0_edn_req
        }
        width: 1
        type: req_rsp
        default: "'0"
        direction: out
        conn_type: false
        index: 3
        netname: edn0_edn_req
      }
      {
        package: edn_pkg
        struct: edn_rsp
        domain: Aon
        inter_pd: true
        signame: edn0_edn_rsp_i
        signame_chip:
        {
          verilator: edn0_edn_rsp
        }
        width: 1
        type: req_rsp
        default: "'0"
        direction: in
        conn_type: false
        index: 3
        netname: edn0_edn_rsp
      }
      {
        package: otp_ctrl_pkg
        struct: sram_otp_key_req
        domain: Main
        inter_pd: true
        signame: otp_ctrl_sram_otp_key_req_i
        signame_chip:
        {
          verilator: otp_ctrl_sram_otp_key_req
        }
        width: 1
        type: req_rsp
        default: "'0"
        direction: in
        conn_type: true
        index: 1
        netname: otp_ctrl_sram_otp_key_req
      }
      {
        package: otp_ctrl_pkg
        struct: sram_otp_key_rsp
        domain: Main
        inter_pd: true
        signame: otp_ctrl_sram_otp_key_rsp_o
        signame_chip:
        {
          verilator: otp_ctrl_sram_otp_key_rsp
        }
        width: 1
        type: req_rsp
        default: "'0"
        direction: out
        conn_type: true
        index: 1
        netname: otp_ctrl_sram_otp_key_rsp
      }
      {
        package: otp_ctrl_pkg
        struct: sram_otp_key_req
        domain: Aon
        inter_pd: true
        signame: otp_ctrl_sram_otp_key_req_o
        signame_chip:
        {
          verilator: otp_ctrl_sram_otp_key_req
        }
        width: 1
        type: req_rsp
        default: "'0"
        direction: out
        conn_type: false
        index: 1
        netname: otp_ctrl_sram_otp_key_req
      }
      {
        package: otp_ctrl_pkg
        struct: sram_otp_key_rsp
        domain: Aon
        inter_pd: true
        signame: otp_ctrl_sram_otp_key_rsp_i
        signame_chip:
        {
          verilator: otp_ctrl_sram_otp_key_rsp
        }
        width: 1
        type: req_rsp
        default: "'0"
        direction: in
        conn_type: false
        index: 1
        netname: otp_ctrl_sram_otp_key_rsp
      }
      {
        package: lc_ctrl_pkg
        struct: lc_tx
        domain: Main
        inter_pd: true
        signame: lc_ctrl_lc_dft_en_o
        signame_chip:
        {
          verilator: lc_ctrl_lc_dft_en
        }
        width: 1
        type: uni
        default: lc_ctrl_pkg::Off
        direction: out
        conn_type: true
        index: -1
        netname: lc_ctrl_lc_dft_en
      }
      {
        package: lc_ctrl_pkg
        struct: lc_tx
        domain: Aon
        inter_pd: true
        signame: lc_ctrl_lc_dft_en_i
        signame_chip:
        {
          verilator: lc_ctrl_lc_dft_en
        }
        width: 1
        type: uni
        default: lc_ctrl_pkg::Off
        direction: in
        conn_type: false
        index: -1
        netname: lc_ctrl_lc_dft_en
      }
      {
        package: lc_ctrl_pkg
        struct: lc_tx
        domain: Main
        inter_pd: true
        signame: lc_ctrl_lc_hw_debug_en_o
        signame_chip:
        {
          verilator: lc_ctrl_lc_hw_debug_en
        }
        width: 1
        type: uni
        default: lc_ctrl_pkg::Off
        direction: out
        conn_type: true
        index: -1
        netname: lc_ctrl_lc_hw_debug_en
      }
      {
        package: lc_ctrl_pkg
        struct: lc_tx
        domain: Aon
        inter_pd: true
        signame: lc_ctrl_lc_hw_debug_en_i
        signame_chip:
        {
          verilator: lc_ctrl_lc_hw_debug_en
        }
        width: 1
        type: uni
        default: lc_ctrl_pkg::Off
        direction: in
        conn_type: false
        index: -1
        netname: lc_ctrl_lc_hw_debug_en
      }
      {
        package: lc_ctrl_pkg
        struct: lc_tx
        domain: Main
        inter_pd: true
        signame: lc_ctrl_lc_escalate_en_o
        signame_chip:
        {
          verilator: lc_ctrl_lc_escalate_en
        }
        width: 1
        type: uni
        default: lc_ctrl_pkg::Off
        direction: out
        conn_type: true
        index: -1
        netname: lc_ctrl_lc_escalate_en
      }
      {
        package: lc_ctrl_pkg
        struct: lc_tx
        domain: Aon
        inter_pd: true
        signame: lc_ctrl_lc_escalate_en_i
        signame_chip:
        {
          verilator: lc_ctrl_lc_escalate_en
        }
        width: 1
        type: uni
        default: lc_ctrl_pkg::Off
        direction: in
        conn_type: false
        index: -1
        netname: lc_ctrl_lc_escalate_en
      }
      {
        package: rv_core_ibex_pkg
        struct: cpu_crash_dump
        domain: Main
        inter_pd: true
        signame: rv_core_ibex_crash_dump_o
        signame_chip:
        {
          verilator: rv_core_ibex_crash_dump
        }
        width: 1
        type: uni
        default: ""
        direction: out
        conn_type: false
        index: -1
        netname: rv_core_ibex_crash_dump
      }
      {
        package: rv_core_ibex_pkg
        struct: cpu_crash_dump
        domain: Aon
        inter_pd: true
        signame: rv_core_ibex_crash_dump_i
        signame_chip:
        {
          verilator: rv_core_ibex_crash_dump
        }
        width: 1
        type: uni
        default: ""
        direction: in
        conn_type: false
        index: -1
        netname: rv_core_ibex_crash_dump
      }
      {
        package: rv_core_ibex_pkg
        struct: cpu_pwrmgr
        domain: Main
        inter_pd: true
        signame: rv_core_ibex_pwrmgr_o
        signame_chip:
        {
          verilator: rv_core_ibex_pwrmgr
        }
        width: 1
        type: uni
        default: ""
        direction: out
        conn_type: false
        index: -1
        netname: rv_core_ibex_pwrmgr
      }
      {
        package: rv_core_ibex_pkg
        struct: cpu_pwrmgr
        domain: Aon
        inter_pd: true
        signame: rv_core_ibex_pwrmgr_i
        signame_chip:
        {
          verilator: rv_core_ibex_pwrmgr
        }
        width: 1
        type: uni
        default: ""
        direction: in
        conn_type: false
        index: -1
        netname: rv_core_ibex_pwrmgr
      }
      {
        package: ""
        struct: logic
        domain: Main
        inter_pd: true
        signame: rv_dm_ndmreset_req_o
        signame_chip:
        {
          verilator: rv_dm_ndmreset_req
        }
        width: 1
        type: uni
        default: ""
        direction: out
        conn_type: false
        index: -1
        netname: rv_dm_ndmreset_req
      }
      {
        package: ""
        struct: logic
        domain: Aon
        inter_pd: true
        signame: rv_dm_ndmreset_req_i
        signame_chip:
        {
          verilator: rv_dm_ndmreset_req
        }
        width: 1
        type: uni
        default: ""
        direction: in
        conn_type: false
        index: -1
        netname: rv_dm_ndmreset_req
      }
      {
        package: tlul_pkg
        struct: tl_h2d
        domain: Main
        inter_pd: true
        signame: main_tl_aon_req_o
        signame_chip:
        {
          verilator: main_tl_aon_req
        }
        width: 1
        type: req_rsp
        default: ""
        direction: out
        conn_type: false
        index: -1
        netname: main_tl_aon_h2d
      }
      {
        package: tlul_pkg
        struct: tl_d2h
        domain: Main
        inter_pd: true
        signame: main_tl_aon_rsp_i
        signame_chip:
        {
          verilator: main_tl_aon_rsp
        }
        width: 1
        type: req_rsp
        default: ""
        direction: in
        conn_type: false
        index: -1
        netname: main_tl_aon_d2h
      }
      {
        package: tlul_pkg
        struct: tl_h2d
        domain: Aon
        inter_pd: true
        signame: main_tl_aon_req_i
        signame_chip:
        {
          verilator: main_tl_aon_req
        }
        width: 1
        type: req_rsp
        default: ""
        direction: in
        conn_type: false
        index: -1
        netname: main_tl_aon_h2d
      }
      {
        package: tlul_pkg
        struct: tl_d2h
        domain: Aon
        inter_pd: true
        signame: main_tl_aon_rsp_o
        signame_chip:
        {
          verilator: main_tl_aon_rsp
        }
        width: 1
        type: req_rsp
        default: ""
        direction: out
        conn_type: false
        index: -1
        netname: main_tl_aon_d2h
      }
      {
        package: ""
        struct: logic
        domain: Aon
        inter_pd: false
        signame: wakeup_main_i
        signame_chip:
        {
          verilator: wakeup_main
        }
        width: 1
        type: uni
        default: ""
        direction: in
        conn_type: false
        index: -1
        netname: wakeup_main
      }
      {
        package: ""
        struct: logic
        domain: Main
        inter_pd: false
        signame: es_rng_enable_o
        signame_chip:
        {
          verilator: es_rng_enable
        }
        width: 1
        type: uni
        default: ""
        direction: out
        conn_type: false
        index: -1
        netname: es_rng_enable
      }
      {
        package: ""
        struct: logic
        domain: Main
        inter_pd: false
        signame: es_rng_valid_i
        signame_chip:
        {
          verilator: es_rng_valid
        }
        width: 1
        type: uni
        default: ""
        direction: in
        conn_type: false
        index: -1
        netname: es_rng_valid
      }
      {
        package: ""
        struct: logic
        domain: Main
        inter_pd: false
        signame: es_rng_bit_i
        signame_chip:
        {
          verilator: es_rng_bit
        }
        width:
        {
          name: RngBusWidth
          desc:
            '''
            Defines the bit-width of the noise source data.
            Must be between 4 and 256 (inclusive) and divisible by 4.
            The divisibility by 4 is a prerequisite for the bucket health test.
            '''
          param_type: int
          unpacked_dimensions: null
          default: 4
          local: false
          expose: true
          name_top: EntropySrcRngBusWidth
        }
        type: uni
        default: ""
        direction: in
        conn_type: false
        index: -1
        netname: es_rng_bit
      }
      {
        package: ""
        struct: logic
        domain: Main
        inter_pd: false
        signame: es_rng_fips_o
        signame_chip:
        {
          verilator: es_rng_fips
        }
        width: 1
        type: uni
        default: ""
        direction: out
        conn_type: false
        index: -1
        netname: es_rng_fips
      }
      {
        package: ""
        struct: logic
        domain: Main
        inter_pd: false
        signame: mbx0_doe_intr_o
        signame_chip:
        {
          verilator: mbx0_doe_intr
        }
        width: 1
        type: uni
        default: 1'b0
        direction: out
        conn_type: false
        index: -1
        netname: mbx0_doe_intr
      }
      {
        package: ""
        struct: logic
        domain: Main
        inter_pd: false
        signame: mbx0_doe_intr_en_o
        signame_chip:
        {
          verilator: mbx0_doe_intr_en
        }
        width: 1
        type: uni
        default: 1'b0
        direction: out
        conn_type: false
        index: -1
        netname: mbx0_doe_intr_en
      }
      {
        package: ""
        struct: logic
        domain: Main
        inter_pd: false
        signame: mbx0_doe_intr_support_o
        signame_chip:
        {
          verilator: mbx0_doe_intr_support
        }
        width: 1
        type: uni
        default: 1'b0
        direction: out
        conn_type: false
        index: -1
        netname: mbx0_doe_intr_support
      }
      {
        package: ""
        struct: logic
        domain: Main
        inter_pd: false
        signame: mbx0_doe_async_msg_support_o
        signame_chip:
        {
          verilator: mbx0_doe_async_msg_support
        }
        width: 1
        type: uni
        default: 1'b0
        direction: out
        conn_type: false
        index: -1
        netname: mbx0_doe_async_msg_support
      }
      {
        package: ""
        struct: logic
        domain: Main
        inter_pd: false
        signame: mbx1_doe_intr_o
        signame_chip:
        {
          verilator: mbx1_doe_intr
        }
        width: 1
        type: uni
        default: 1'b0
        direction: out
        conn_type: false
        index: -1
        netname: mbx1_doe_intr
      }
      {
        package: ""
        struct: logic
        domain: Main
        inter_pd: false
        signame: mbx1_doe_intr_en_o
        signame_chip:
        {
          verilator: mbx1_doe_intr_en
        }
        width: 1
        type: uni
        default: 1'b0
        direction: out
        conn_type: false
        index: -1
        netname: mbx1_doe_intr_en
      }
      {
        package: ""
        struct: logic
        domain: Main
        inter_pd: false
        signame: mbx1_doe_intr_support_o
        signame_chip:
        {
          verilator: mbx1_doe_intr_support
        }
        width: 1
        type: uni
        default: 1'b0
        direction: out
        conn_type: false
        index: -1
        netname: mbx1_doe_intr_support
      }
      {
        package: ""
        struct: logic
        domain: Main
        inter_pd: false
        signame: mbx1_doe_async_msg_support_o
        signame_chip:
        {
          verilator: mbx1_doe_async_msg_support
        }
        width: 1
        type: uni
        default: 1'b0
        direction: out
        conn_type: false
        index: -1
        netname: mbx1_doe_async_msg_support
      }
      {
        package: ahb_pkg
        struct: ahb_m2s
        domain: Main
        inter_pd: false
        signame: soc_mgr_ahb_req_o
        signame_chip:
        {
          verilator: soc_mgr_ahb_req_o
        }
        width: 1
        type: uni
        default: ""
        direction: out
        conn_type: false
        index: -1
        netname: soc_mgr_ahb_req
      }
      {
        package: ahb_pkg
        struct: ahb_s2m
        domain: Main
        inter_pd: false
        signame: soc_mgr_ahb_rsp_i
        signame_chip:
        {
          verilator: soc_mgr_ahb_rsp_i
        }
        width: 1
        type: uni
        default: ""
        direction: in
        conn_type: false
        index: -1
        netname: soc_mgr_ahb_rsp
      }
      {
        package: ahb_pkg
        struct: ahb_m2s
        domain: Main
        inter_pd: false
        signame: soc_mbx_ahb_req_i
        signame_chip:
        {
          verilator: soc_mbx_ahb_req_i
        }
        width: 1
        type: uni
        default: ""
        direction: in
        conn_type: false
        index: -1
        netname: soc_mbx_ahb_req
      }
      {
        package: ahb_pkg
        struct: ahb_s2m
        domain: Main
        inter_pd: false
        signame: soc_mbx_ahb_rsp_o
        signame_chip:
        {
          verilator: soc_mbx_ahb_rsp_o
        }
        width: 1
        type: uni
        default: ""
        direction: out
        conn_type: false
        index: -1
        netname: soc_mbx_ahb_rsp
      }
      {
        package: tlul_pkg
        struct: tl_h2d
        domain: Main
        inter_pd: false
        signame: soc_dbg_tl_req_i
        signame_chip:
        {
          verilator: soc_dbg_tl_req
        }
        width: 1
        type: req_rsp
        default: ""
        direction: in
        conn_type: false
        index: -1
        netname: soc_dbg_tl_h2d
      }
      {
        package: tlul_pkg
        struct: tl_d2h
        domain: Main
        inter_pd: false
        signame: soc_dbg_tl_rsp_o
        signame_chip:
        {
          verilator: soc_dbg_tl_rsp
        }
        width: 1
        type: req_rsp
        default: ""
        direction: out
        conn_type: false
        index: -1
        netname: soc_dbg_tl_d2h
      }
    ]
    definitions:
    [
      {
        package: pwrmgr_pkg
        struct: pwr_rst_req
        domain: Aon
        signame: pwrmgr_pwr_rst_req
        width: 1
        type: req_rsp
        end_idx: -1
        act: req
        suffix: req
        default: ""
      }
      {
        package: pwrmgr_pkg
        struct: pwr_rst_rsp
        domain: Aon
        signame: pwrmgr_pwr_rst_rsp
        width: 1
        type: req_rsp
        end_idx: -1
        act: req
        suffix: rsp
        default: pwrmgr_pkg::PWR_RST_RSP_DEFAULT
      }
      {
        package: pwrmgr_pkg
        struct: pwr_clk_req
        domain: Aon
        signame: pwrmgr_pwr_clk_req
        width: 1
        type: req_rsp
        end_idx: -1
        act: req
        suffix: req
        default: ""
      }
      {
        package: pwrmgr_pkg
        struct: pwr_clk_rsp
        domain: Aon
        signame: pwrmgr_pwr_clk_rsp
        width: 1
        type: req_rsp
        end_idx: -1
        act: req
        suffix: rsp
        default: pwrmgr_pkg::PWR_CLK_RSP_DEFAULT
      }
      {
        package: prim_esc_pkg
        struct: esc_rx
        domain: Aon
        signame: alert_handler_esc_rx
        width: 4
        type: uni
        end_idx: -1
        act: rcv
        suffix: ""
        default: "'{default: prim_esc_pkg::ESC_RX_DEFAULT}"
      }
      {
        package: prim_esc_pkg
        struct: esc_tx
        domain: Aon
        signame: alert_handler_esc_tx
        width: 4
        type: uni
        end_idx: -1
        act: req
        suffix: ""
        default: "'{default: prim_esc_pkg::ESC_TX_DEFAULT}"
      }
      {
        package: alert_handler_pkg
        struct: alert_crashdump
        domain: Aon
        signame: alert_handler_crashdump
        width: 1
        type: uni
        end_idx: -1
        act: req
        suffix: ""
        default: alert_handler_pkg::ALERT_CRASHDUMP_DEFAULT
      }
      {
        package: csrng_pkg
        struct: csrng_req
        domain: Main
        signame: csrng_csrng_cmd_req
        width: 2
        type: req_rsp
        end_idx: -1
        act: rsp
        suffix: req
        default: "'{default: csrng_pkg::CSRNG_REQ_DEFAULT}"
      }
      {
        package: csrng_pkg
        struct: csrng_rsp
        domain: Main
        signame: csrng_csrng_cmd_rsp
        width: 2
        type: req_rsp
        end_idx: -1
        act: rsp
        suffix: rsp
        default: ""
      }
      {
        package: entropy_src_pkg
        struct: entropy_src_hw_if_req
        domain: Main
        signame: csrng_entropy_src_hw_if_req
        width: 1
        type: req_rsp
        end_idx: -1
        act: req
        suffix: req
        default: ""
      }
      {
        package: entropy_src_pkg
        struct: entropy_src_hw_if_rsp
        domain: Main
        signame: csrng_entropy_src_hw_if_rsp
        width: 1
        type: req_rsp
        end_idx: -1
        act: req
        suffix: rsp
        default: entropy_src_pkg::ENTROPY_SRC_HW_IF_RSP_DEFAULT
      }
      {
        package: edn_pkg
        struct: edn_req
        domain: Main
        signame: edn0_edn_req
        width:
        {
          name: NumEndPoints
          desc: Number of endpoints
          param_type: int unsigned
          unpacked_dimensions: null
          default: 8
          local: true
          expose: true
          name_top: Edn0NumEndPoints
        }
        type: req_rsp
        end_idx: 7
        act: rsp
        suffix: req
        default: "'0"
      }
      {
        package: edn_pkg
        struct: edn_rsp
        domain: Main
        signame: edn0_edn_rsp
        width:
        {
          name: NumEndPoints
          desc: Number of endpoints
          param_type: int unsigned
          unpacked_dimensions: null
          default: 8
          local: true
          expose: true
          name_top: Edn0NumEndPoints
        }
        type: req_rsp
        end_idx: 7
        act: rsp
        suffix: rsp
        default: "'0"
      }
      {
        package: edn_pkg
        struct: edn_req
        domain: Main
        signame: edn1_edn_req
        width:
        {
          name: NumEndPoints
          desc: Number of endpoints
          param_type: int unsigned
          unpacked_dimensions: null
          default: 8
          local: true
          expose: true
          name_top: Edn1NumEndPoints
        }
        type: req_rsp
        end_idx: -1
        act: rsp
        suffix: req
        default: "'{default: '0}"
      }
      {
        package: edn_pkg
        struct: edn_rsp
        domain: Main
        signame: edn1_edn_rsp
        width:
        {
          name: NumEndPoints
          desc: Number of endpoints
          param_type: int unsigned
          unpacked_dimensions: null
          default: 8
          local: true
          expose: true
          name_top: Edn1NumEndPoints
        }
        type: req_rsp
        end_idx: -1
        act: rsp
        suffix: rsp
        default: ""
      }
      {
        package: otp_ctrl_pkg
        struct: sram_otp_key_req
        domain: Main
        signame: otp_ctrl_sram_otp_key_req
        width: 4
        type: req_rsp
        end_idx: 3
        act: rsp
        suffix: req
        default: "'0"
      }
      {
        package: otp_ctrl_pkg
        struct: sram_otp_key_rsp
        domain: Main
        signame: otp_ctrl_sram_otp_key_rsp
        width: 4
        type: req_rsp
        end_idx: 3
        act: rsp
        suffix: rsp
        default: "'0"
      }
      {
        package: otp_ctrl_pkg
        struct: otbn_otp_key_req
        domain: Main
        signame: otp_ctrl_otbn_otp_key_req
        width: 1
        type: req_rsp
        end_idx: -1
        act: rsp
        suffix: req
        default: "'0"
      }
      {
        package: otp_ctrl_pkg
        struct: otbn_otp_key_rsp
        domain: Main
        signame: otp_ctrl_otbn_otp_key_rsp
        width: 1
        type: req_rsp
        end_idx: -1
        act: rsp
        suffix: rsp
        default: ""
      }
      {
        package: keymgr_dpe_pkg
        struct: keymgr_dpe_creator_root_key
        domain: Main
        signame: otp_ctrl_keymgr_creator_root_key
        width: 1
        type: uni
        end_idx: -1
        act: req
        suffix: ""
        default: "'0"
      }
      {
        package: keymgr_dpe_pkg
        struct: keymgr_dpe_creator_seed
        domain: Main
        signame: otp_ctrl_keymgr_creator_seed
        width: 1
        type: uni
        end_idx: -1
        act: req
        suffix: ""
        default: "'0"
      }
      {
        package: keymgr_dpe_pkg
        struct: keymgr_dpe_owner_seed
        domain: Main
        signame: otp_ctrl_keymgr_owner_seed
        width: 1
        type: uni
        end_idx: -1
        act: req
        suffix: ""
        default: "'0"
      }
      {
        package: otp_ctrl_macro_pkg
        struct: otp_ctrl_macro_req
        domain: Main
        signame: otp_ctrl_otp_macro_req
        width: 1
        type: req_rsp
        end_idx: -1
        act: req
        suffix: req
        default: ""
      }
      {
        package: otp_ctrl_macro_pkg
        struct: otp_ctrl_macro_rsp
        domain: Main
        signame: otp_ctrl_otp_macro_rsp
        width: 1
        type: req_rsp
        end_idx: -1
        act: req
        suffix: rsp
        default: "'0"
      }
      {
        package: rom_ctrl_pkg
        struct: keymgr_data
        domain: Main
        signame: keymgr_dpe_rom_digest
        width:
        {
          name: NumRomDigestInputs
          desc: Number of digest inputs from ROM_CTRL
          param_type: int
          unpacked_dimensions: null
          default: 2
          local: false
          expose: true
          name_top: KeymgrDpeNumRomDigestInputs
        }
        type: uni
        end_idx: -1
        act: rcv
        suffix: ""
        default: "'{default: rom_ctrl_pkg::KEYMGR_DATA_DEFAULT}"
      }
      {
        package: keymgr_pkg
        struct: hw_key_req
        domain: Main
        signame: keymgr_dpe_aes_key
        width: 1
        type: uni
        end_idx: -1
        act: req
        suffix: ""
        default: keymgr_pkg::HW_KEY_REQ_DEFAULT
      }
      {
        package: keymgr_pkg
        struct: hw_key_req
        domain: Main
        signame: keymgr_dpe_kmac_key
        width: 1
        type: uni
        end_idx: -1
        act: req
        suffix: ""
        default: keymgr_pkg::HW_KEY_REQ_DEFAULT
      }
      {
        package: keymgr_pkg
        struct: otbn_key_req
        domain: Main
        signame: keymgr_dpe_otbn_key
        width: 1
        type: uni
        end_idx: -1
        act: req
        suffix: ""
        default: keymgr_pkg::OTBN_KEY_REQ_DEFAULT
      }
      {
        package: kmac_pkg
        struct: app_req
        domain: Main
        signame: kmac_app_req
        width:
        {
          name: NumAppIntf
          desc: Number of application interfaces
          param_type: int
          unpacked_dimensions: null
          default: 4
          local: false
          expose: true
          name_top: KmacNumAppIntf
        }
        type: req_rsp
        end_idx: -1
        act: rsp
        suffix: req
        default: "'{default: kmac_pkg::APP_REQ_DEFAULT}"
      }
      {
        package: kmac_pkg
        struct: app_rsp
        domain: Main
        signame: kmac_app_rsp
        width:
        {
          name: NumAppIntf
          desc: Number of application interfaces
          param_type: int
          unpacked_dimensions: null
          default: 4
          local: false
          expose: true
          name_top: KmacNumAppIntf
        }
        type: req_rsp
        end_idx: -1
        act: rsp
        suffix: rsp
        default: ""
      }
      {
        package: ""
        struct: logic
        domain: Main
        signame: kmac_en_masking
        width: 1
        type: uni
        end_idx: -1
        act: req
        suffix: ""
        default: 1'b0
      }
      {
        package: lc_ctrl_pkg
        struct: lc_tx
        domain: Main
        signame: lc_ctrl_lc_nvm_rma_req
        width: 1
        type: uni
        end_idx: -1
        act: req
        suffix: ""
        default: lc_ctrl_pkg::Off
      }
      {
        package: lc_ctrl_pkg
        struct: lc_tx
        domain: Main
        signame: otbn_lc_rma_ack
        width: 1
        type: uni
        end_idx: -1
        act: req
        suffix: ""
        default: lc_ctrl_pkg::Off
      }
      {
        package: lc_ctrl_pkg
        struct: lc_tx
        domain: Main
        signame: lc_ctrl_lc_clk_byp_ack
        width: 1
        type: uni
        end_idx: -1
        act: rcv
        suffix: ""
        default: lc_ctrl_pkg::Off
      }
      {
        package: otp_ctrl_pkg
        struct: otp_lc_data
        domain: Main
        signame: otp_ctrl_otp_lc_data
        width: 1
        type: uni
        end_idx: -1
        act: req
        suffix: ""
        default: "'0"
      }
      {
        package: otp_ctrl_pkg
        struct: lc_otp_program_req
        domain: Main
        signame: lc_ctrl_lc_otp_program_req
        width: 1
        type: req_rsp
        end_idx: -1
        act: req
        suffix: req
        default: ""
      }
      {
        package: otp_ctrl_pkg
        struct: lc_otp_program_rsp
        domain: Main
        signame: lc_ctrl_lc_otp_program_rsp
        width: 1
        type: req_rsp
        end_idx: -1
        act: req
        suffix: rsp
        default: "'0"
      }
      {
        package: otp_macro_pkg
        struct: otp_test_req
        domain: Main
        signame: lc_ctrl_lc_otp_vendor_test_req
        width: 1
        type: req_rsp
        end_idx: -1
        act: req
        suffix: req
        default: ""
      }
      {
        package: otp_macro_pkg
        struct: otp_test_rsp
        domain: Main
        signame: lc_ctrl_lc_otp_vendor_test_rsp
        width: 1
        type: req_rsp
        end_idx: -1
        act: req
        suffix: rsp
        default: "'0"
      }
      {
        package: lc_ctrl_pkg
        struct: lc_keymgr_div
        domain: Main
        signame: lc_ctrl_lc_keymgr_div
        width: 1
        type: uni
        end_idx: -1
        act: req
        suffix: ""
        default: "'0"
      }
      {
        package: ""
        struct: logic
        domain: Main
        signame: lc_ctrl_strap_en_override
        width: 1
        type: uni
        end_idx: -1
        act: req
        suffix: ""
        default: 1'b0
      }
      {
        package: lc_ctrl_pkg
        struct: lc_tx
        domain: Main
        signame: lc_ctrl_lc_dft_en
        width: 1
        type: uni
        end_idx: -1
        act: req
        suffix: ""
        default: lc_ctrl_pkg::Off
      }
      {
        package: lc_ctrl_pkg
        struct: lc_tx
        domain: Main
        signame: lc_ctrl_lc_hw_debug_clr
        width: 1
        type: uni
        end_idx: -1
        act: req
        suffix: ""
        default: lc_ctrl_pkg::Off
      }
      {
        package: lc_ctrl_pkg
        struct: lc_tx
        domain: Main
        signame: lc_ctrl_lc_init_done
        width: 1
        type: uni
        end_idx: -1
        act: req
        suffix: ""
        default: lc_ctrl_pkg::Off
      }
      {
        package: lc_ctrl_pkg
        struct: lc_tx
        domain: Main
        signame: lc_ctrl_lc_hw_debug_en
        width: 1
        type: uni
        end_idx: -1
        act: req
        suffix: ""
        default: lc_ctrl_pkg::Off
      }
      {
        package: lc_ctrl_pkg
        struct: lc_tx
        domain: Main
        signame: lc_ctrl_lc_cpu_en
        width: 1
        type: uni
        end_idx: -1
        act: req
        suffix: ""
        default: lc_ctrl_pkg::Off
      }
      {
        package: lc_ctrl_pkg
        struct: lc_tx
        domain: Main
        signame: lc_ctrl_lc_keymgr_en
        width: 1
        type: uni
        end_idx: -1
        act: req
        suffix: ""
        default: lc_ctrl_pkg::Off
      }
      {
        package: lc_ctrl_pkg
        struct: lc_tx
        domain: Main
        signame: lc_ctrl_lc_escalate_en
        width: 1
        type: uni
        end_idx: -1
        act: req
        suffix: ""
        default: lc_ctrl_pkg::Off
      }
      {
        package: lc_ctrl_pkg
        struct: lc_tx
        domain: Main
        signame: lc_ctrl_lc_check_byp_en
        width: 1
        type: uni
        end_idx: -1
        act: req
        suffix: ""
        default: lc_ctrl_pkg::Off
      }
      {
        package: lc_ctrl_pkg
        struct: lc_tx
        domain: Main
        signame: lc_ctrl_lc_creator_seed_sw_rw_en
        width: 1
        type: uni
        end_idx: -1
        act: req
        suffix: ""
        default: lc_ctrl_pkg::Off
      }
      {
        package: lc_ctrl_pkg
        struct: lc_tx
        domain: Main
        signame: lc_ctrl_lc_owner_seed_sw_rw_en
        width: 1
        type: uni
        end_idx: -1
        act: req
        suffix: ""
        default: lc_ctrl_pkg::Off
      }
      {
        package: lc_ctrl_pkg
        struct: lc_tx
        domain: Main
        signame: lc_ctrl_lc_seed_hw_rd_en
        width: 1
        type: uni
        end_idx: -1
        act: req
        suffix: ""
        default: lc_ctrl_pkg::Off
      }
      {
        package: lc_ctrl_pkg
        struct: lc_tx
        domain: Main
        signame: lc_ctrl_lc_rma_state
        width: 1
        type: uni
        end_idx: -1
        act: req
        suffix: ""
        default: lc_ctrl_pkg::Off
      }
      {
        package: ""
        struct: logic
        domain: Main
        signame: rv_plic_msip
        width: 1
        type: uni
        end_idx: -1
        act: req
        suffix: ""
        default: 1'b0
      }
      {
        package: ""
        struct: logic
        domain: Main
        signame: rv_plic_irq
        width: 1
        type: uni
        end_idx: -1
        act: req
        suffix: ""
        default: 1'b0
      }
      {
        package: ""
        struct: logic [rv_dm_reg_pkg::NrHarts-1:0]
        domain: Main
        signame: rv_dm_debug_req
        width: 1
        type: uni
        end_idx: -1
        act: req
        suffix: ""
        default: "'0"
      }
      {
        package: prim_mubi_pkg
        struct: mubi4
        domain: Aon
        signame: rstmgr_sw_rst_req
        width: 1
        type: uni
        end_idx: -1
        act: req
        suffix: ""
        default: prim_mubi_pkg::MUBI4_DEFAULT
      }
      {
        package: tlul_pkg
        struct: tl_h2d
        domain: Main
        signame: main_tl_rv_core_ibex__corei_req
        width: 1
        type: req_rsp
        end_idx: -1
        act: rsp
        suffix: req
        default: tlul_pkg::TL_H2D_DEFAULT
      }
      {
        package: tlul_pkg
        struct: tl_d2h
        domain: Main
        signame: main_tl_rv_core_ibex__corei_rsp
        width: 1
        type: req_rsp
        end_idx: -1
        act: rsp
        suffix: rsp
        default: ""
      }
      {
        package: tlul_pkg
        struct: tl_h2d
        domain: Main
        signame: main_tl_rv_core_ibex__cored_req
        width: 1
        type: req_rsp
        end_idx: -1
        act: rsp
        suffix: req
        default: tlul_pkg::TL_H2D_DEFAULT
      }
      {
        package: tlul_pkg
        struct: tl_d2h
        domain: Main
        signame: main_tl_rv_core_ibex__cored_rsp
        width: 1
        type: req_rsp
        end_idx: -1
        act: rsp
        suffix: rsp
        default: ""
      }
      {
        package: tlul_pkg
        struct: tl_h2d
        domain: Main
        signame: main_tl_rv_dm__sba_req
        width: 1
        type: req_rsp
        end_idx: -1
        act: rsp
        suffix: req
        default: tlul_pkg::TL_H2D_DEFAULT
      }
      {
        package: tlul_pkg
        struct: tl_d2h
        domain: Main
        signame: main_tl_rv_dm__sba_rsp
        width: 1
        type: req_rsp
        end_idx: -1
        act: rsp
        suffix: rsp
        default: ""
      }
      {
        package: tlul_pkg
        struct: tl_h2d
        domain: Main
        signame: main_tl_dma__host_req
        width: 1
        type: req_rsp
        end_idx: -1
        act: rsp
        suffix: req
        default: tlul_pkg::TL_H2D_DEFAULT
      }
      {
        package: tlul_pkg
        struct: tl_d2h
        domain: Main
        signame: main_tl_dma__host_rsp
        width: 1
        type: req_rsp
        end_idx: -1
        act: rsp
        suffix: rsp
        default: ""
      }
      {
        package: tlul_pkg
        struct: tl_h2d
        domain: Main
        signame: main_tl_mbx0__sram_req
        width: 1
        type: req_rsp
        end_idx: -1
        act: rsp
        suffix: req
        default: tlul_pkg::TL_H2D_DEFAULT
      }
      {
        package: tlul_pkg
        struct: tl_d2h
        domain: Main
        signame: main_tl_mbx0__sram_rsp
        width: 1
        type: req_rsp
        end_idx: -1
        act: rsp
        suffix: rsp
        default: ""
      }
      {
        package: tlul_pkg
        struct: tl_h2d
        domain: Main
        signame: main_tl_mbx1__sram_req
        width: 1
        type: req_rsp
        end_idx: -1
        act: rsp
        suffix: req
        default: tlul_pkg::TL_H2D_DEFAULT
      }
      {
        package: tlul_pkg
        struct: tl_d2h
        domain: Main
        signame: main_tl_mbx1__sram_rsp
        width: 1
        type: req_rsp
        end_idx: -1
        act: rsp
        suffix: rsp
        default: ""
      }
      {
        package: tlul_pkg
        struct: tl_h2d
        domain: Main
        signame: rv_dm_regs_tl_d_req
        width: 1
        type: req_rsp
        end_idx: -1
        act: rsp
        suffix: req
        default: tlul_pkg::TL_H2D_DEFAULT
      }
      {
        package: tlul_pkg
        struct: tl_d2h
        domain: Main
        signame: rv_dm_regs_tl_d_rsp
        width: 1
        type: req_rsp
        end_idx: -1
        act: rsp
        suffix: rsp
        default: ""
      }
      {
        package: tlul_pkg
        struct: tl_h2d
        domain: Main
        signame: rv_dm_mem_tl_d_req
        width: 1
        type: req_rsp
        end_idx: -1
        act: rsp
        suffix: req
        default: tlul_pkg::TL_H2D_DEFAULT
      }
      {
        package: tlul_pkg
        struct: tl_d2h
        domain: Main
        signame: rv_dm_mem_tl_d_rsp
        width: 1
        type: req_rsp
        end_idx: -1
        act: rsp
        suffix: rsp
        default: ""
      }
      {
        package: tlul_pkg
        struct: tl_h2d
        domain: Main
        signame: rom_ctrl_rom_tl_req
        width: 1
        type: req_rsp
        end_idx: -1
        act: rsp
        suffix: req
        default: tlul_pkg::TL_H2D_DEFAULT
      }
      {
        package: tlul_pkg
        struct: tl_d2h
        domain: Main
        signame: rom_ctrl_rom_tl_rsp
        width: 1
        type: req_rsp
        end_idx: -1
        act: rsp
        suffix: rsp
        default: ""
      }
      {
        package: tlul_pkg
        struct: tl_h2d
        domain: Main
        signame: rom_ctrl_regs_tl_req
        width: 1
        type: req_rsp
        end_idx: -1
        act: rsp
        suffix: req
        default: tlul_pkg::TL_H2D_DEFAULT
      }
      {
        package: tlul_pkg
        struct: tl_d2h
        domain: Main
        signame: rom_ctrl_regs_tl_rsp
        width: 1
        type: req_rsp
        end_idx: -1
        act: rsp
        suffix: rsp
        default: ""
      }
      {
        package: tlul_pkg
        struct: tl_h2d
        domain: Main
        signame: sram_ctrl_main_regs_tl_req
        width: 1
        type: req_rsp
        end_idx: -1
        act: rsp
        suffix: req
        default: tlul_pkg::TL_H2D_DEFAULT
      }
      {
        package: tlul_pkg
        struct: tl_d2h
        domain: Main
        signame: sram_ctrl_main_regs_tl_rsp
        width: 1
        type: req_rsp
        end_idx: -1
        act: rsp
        suffix: rsp
        default: ""
      }
      {
        package: tlul_pkg
        struct: tl_h2d
        domain: Main
        signame: sram_ctrl_main_ram_tl_req
        width: 1
        type: req_rsp
        end_idx: -1
        act: rsp
        suffix: req
        default: tlul_pkg::TL_H2D_DEFAULT
      }
      {
        package: tlul_pkg
        struct: tl_d2h
        domain: Main
        signame: sram_ctrl_main_ram_tl_rsp
        width: 1
        type: req_rsp
        end_idx: -1
        act: rsp
        suffix: rsp
        default: ""
      }
      {
        package: tlul_pkg
        struct: tl_h2d
        domain: Main
        signame: otp_ctrl_core_tl_req
        width: 1
        type: req_rsp
        end_idx: -1
        act: rsp
        suffix: req
        default: tlul_pkg::TL_H2D_DEFAULT
      }
      {
        package: tlul_pkg
        struct: tl_d2h
        domain: Main
        signame: otp_ctrl_core_tl_rsp
        width: 1
        type: req_rsp
        end_idx: -1
        act: rsp
        suffix: rsp
        default: ""
      }
      {
        package: tlul_pkg
        struct: tl_h2d
        domain: Main
        signame: otp_macro_prim_tl_req
        width: 1
        type: req_rsp
        end_idx: -1
        act: rsp
        suffix: req
        default: tlul_pkg::TL_H2D_DEFAULT
      }
      {
        package: tlul_pkg
        struct: tl_d2h
        domain: Main
        signame: otp_macro_prim_tl_rsp
        width: 1
        type: req_rsp
        end_idx: -1
        act: rsp
        suffix: rsp
        default: ""
      }
      {
        package: tlul_pkg
        struct: tl_h2d
        domain: Main
        signame: lc_ctrl_regs_tl_req
        width: 1
        type: req_rsp
        end_idx: -1
        act: rsp
        suffix: req
        default: tlul_pkg::TL_H2D_DEFAULT
      }
      {
        package: tlul_pkg
        struct: tl_d2h
        domain: Main
        signame: lc_ctrl_regs_tl_rsp
        width: 1
        type: req_rsp
        end_idx: -1
        act: rsp
        suffix: rsp
        default: ""
      }
      {
        package: tlul_pkg
        struct: tl_h2d
        domain: Main
        signame: rv_plic_tl_req
        width: 1
        type: req_rsp
        end_idx: -1
        act: rsp
        suffix: req
        default: tlul_pkg::TL_H2D_DEFAULT
      }
      {
        package: tlul_pkg
        struct: tl_d2h
        domain: Main
        signame: rv_plic_tl_rsp
        width: 1
        type: req_rsp
        end_idx: -1
        act: rsp
        suffix: rsp
        default: ""
      }
      {
        package: tlul_pkg
        struct: tl_h2d
        domain: Main
        signame: rv_timer_tl_req
        width: 1
        type: req_rsp
        end_idx: -1
        act: rsp
        suffix: req
        default: tlul_pkg::TL_H2D_DEFAULT
      }
      {
        package: tlul_pkg
        struct: tl_d2h
        domain: Main
        signame: rv_timer_tl_rsp
        width: 1
        type: req_rsp
        end_idx: -1
        act: rsp
        suffix: rsp
        default: ""
      }
      {
        package: tlul_pkg
        struct: tl_h2d
        domain: Main
        signame: aes_tl_req
        width: 1
        type: req_rsp
        end_idx: -1
        act: rsp
        suffix: req
        default: tlul_pkg::TL_H2D_DEFAULT
      }
      {
        package: tlul_pkg
        struct: tl_d2h
        domain: Main
        signame: aes_tl_rsp
        width: 1
        type: req_rsp
        end_idx: -1
        act: rsp
        suffix: rsp
        default: ""
      }
      {
        package: tlul_pkg
        struct: tl_h2d
        domain: Main
        signame: hmac_tl_req
        width: 1
        type: req_rsp
        end_idx: -1
        act: rsp
        suffix: req
        default: tlul_pkg::TL_H2D_DEFAULT
      }
      {
        package: tlul_pkg
        struct: tl_d2h
        domain: Main
        signame: hmac_tl_rsp
        width: 1
        type: req_rsp
        end_idx: -1
        act: rsp
        suffix: rsp
        default: ""
      }
      {
        package: tlul_pkg
        struct: tl_h2d
        domain: Main
        signame: kmac_tl_req
        width: 1
        type: req_rsp
        end_idx: -1
        act: rsp
        suffix: req
        default: tlul_pkg::TL_H2D_DEFAULT
      }
      {
        package: tlul_pkg
        struct: tl_d2h
        domain: Main
        signame: kmac_tl_rsp
        width: 1
        type: req_rsp
        end_idx: -1
        act: rsp
        suffix: rsp
        default: ""
      }
      {
        package: tlul_pkg
        struct: tl_h2d
        domain: Main
        signame: otbn_tl_req
        width: 1
        type: req_rsp
        end_idx: -1
        act: rsp
        suffix: req
        default: tlul_pkg::TL_H2D_DEFAULT
      }
      {
        package: tlul_pkg
        struct: tl_d2h
        domain: Main
        signame: otbn_tl_rsp
        width: 1
        type: req_rsp
        end_idx: -1
        act: rsp
        suffix: rsp
        default: ""
      }
      {
        package: tlul_pkg
        struct: tl_h2d
        domain: Main
        signame: keymgr_dpe_tl_req
        width: 1
        type: req_rsp
        end_idx: -1
        act: rsp
        suffix: req
        default: tlul_pkg::TL_H2D_DEFAULT
      }
      {
        package: tlul_pkg
        struct: tl_d2h
        domain: Main
        signame: keymgr_dpe_tl_rsp
        width: 1
        type: req_rsp
        end_idx: -1
        act: rsp
        suffix: rsp
        default: ""
      }
      {
        package: tlul_pkg
        struct: tl_h2d
        domain: Main
        signame: csrng_tl_req
        width: 1
        type: req_rsp
        end_idx: -1
        act: rsp
        suffix: req
        default: tlul_pkg::TL_H2D_DEFAULT
      }
      {
        package: tlul_pkg
        struct: tl_d2h
        domain: Main
        signame: csrng_tl_rsp
        width: 1
        type: req_rsp
        end_idx: -1
        act: rsp
        suffix: rsp
        default: ""
      }
      {
        package: tlul_pkg
        struct: tl_h2d
        domain: Main
        signame: entropy_src_tl_req
        width: 1
        type: req_rsp
        end_idx: -1
        act: rsp
        suffix: req
        default: tlul_pkg::TL_H2D_DEFAULT
      }
      {
        package: tlul_pkg
        struct: tl_d2h
        domain: Main
        signame: entropy_src_tl_rsp
        width: 1
        type: req_rsp
        end_idx: -1
        act: rsp
        suffix: rsp
        default: ""
      }
      {
        package: tlul_pkg
        struct: tl_h2d
        domain: Main
        signame: edn0_tl_req
        width: 1
        type: req_rsp
        end_idx: -1
        act: rsp
        suffix: req
        default: tlul_pkg::TL_H2D_DEFAULT
      }
      {
        package: tlul_pkg
        struct: tl_d2h
        domain: Main
        signame: edn0_tl_rsp
        width: 1
        type: req_rsp
        end_idx: -1
        act: rsp
        suffix: rsp
        default: ""
      }
      {
        package: tlul_pkg
        struct: tl_h2d
        domain: Main
        signame: edn1_tl_req
        width: 1
        type: req_rsp
        end_idx: -1
        act: rsp
        suffix: req
        default: tlul_pkg::TL_H2D_DEFAULT
      }
      {
        package: tlul_pkg
        struct: tl_d2h
        domain: Main
        signame: edn1_tl_rsp
        width: 1
        type: req_rsp
        end_idx: -1
        act: rsp
        suffix: rsp
        default: ""
      }
      {
        package: tlul_pkg
        struct: tl_h2d
        domain: Main
        signame: rv_core_ibex_cfg_tl_d_req
        width: 1
        type: req_rsp
        end_idx: -1
        act: rsp
        suffix: req
        default: tlul_pkg::TL_H2D_DEFAULT
      }
      {
        package: tlul_pkg
        struct: tl_d2h
        domain: Main
        signame: rv_core_ibex_cfg_tl_d_rsp
        width: 1
        type: req_rsp
        end_idx: -1
        act: rsp
        suffix: rsp
        default: ""
      }
      {
        package: tlul_pkg
        struct: tl_h2d
        domain: Main
        signame: dma_tl_d_req
        width: 1
        type: req_rsp
        end_idx: -1
        act: rsp
        suffix: req
        default: tlul_pkg::TL_H2D_DEFAULT
      }
      {
        package: tlul_pkg
        struct: tl_d2h
        domain: Main
        signame: dma_tl_d_rsp
        width: 1
        type: req_rsp
        end_idx: -1
        act: rsp
        suffix: rsp
        default: ""
      }
      {
        package: tlul_pkg
        struct: tl_h2d
        domain: Main
        signame: ahb_bridge_ctn_tl_d_req
        width: 1
        type: req_rsp
        end_idx: -1
        act: rsp
        suffix: req
        default: tlul_pkg::TL_H2D_DEFAULT
      }
      {
        package: tlul_pkg
        struct: tl_d2h
        domain: Main
        signame: ahb_bridge_ctn_tl_d_rsp
        width: 1
        type: req_rsp
        end_idx: -1
        act: rsp
        suffix: rsp
        default: ""
      }
      {
        package: tlul_pkg
        struct: tl_h2d
        domain: Main
        signame: mbx0_core_tl_d_req
        width: 1
        type: req_rsp
        end_idx: -1
        act: rsp
        suffix: req
        default: tlul_pkg::TL_H2D_DEFAULT
      }
      {
        package: tlul_pkg
        struct: tl_d2h
        domain: Main
        signame: mbx0_core_tl_d_rsp
        width: 1
        type: req_rsp
        end_idx: -1
        act: rsp
        suffix: rsp
        default: ""
      }
      {
        package: tlul_pkg
        struct: tl_h2d
        domain: Main
        signame: mbx1_core_tl_d_req
        width: 1
        type: req_rsp
        end_idx: -1
        act: rsp
        suffix: req
        default: tlul_pkg::TL_H2D_DEFAULT
      }
      {
        package: tlul_pkg
        struct: tl_d2h
        domain: Main
        signame: mbx1_core_tl_d_rsp
        width: 1
        type: req_rsp
        end_idx: -1
        act: rsp
        suffix: rsp
        default: ""
      }
      {
        package: tlul_pkg
        struct: tl_h2d
        domain: Aon
        signame: pwrmgr_tl_req
        width: 1
        type: req_rsp
        end_idx: -1
        act: rsp
        suffix: req
        default: tlul_pkg::TL_H2D_DEFAULT
      }
      {
        package: tlul_pkg
        struct: tl_d2h
        domain: Aon
        signame: pwrmgr_tl_rsp
        width: 1
        type: req_rsp
        end_idx: -1
        act: rsp
        suffix: rsp
        default: ""
      }
      {
        package: tlul_pkg
        struct: tl_h2d
        domain: Aon
        signame: rstmgr_tl_req
        width: 1
        type: req_rsp
        end_idx: -1
        act: rsp
        suffix: req
        default: tlul_pkg::TL_H2D_DEFAULT
      }
      {
        package: tlul_pkg
        struct: tl_d2h
        domain: Aon
        signame: rstmgr_tl_rsp
        width: 1
        type: req_rsp
        end_idx: -1
        act: rsp
        suffix: rsp
        default: ""
      }
      {
        package: tlul_pkg
        struct: tl_h2d
        domain: Aon
        signame: clkmgr_tl_req
        width: 1
        type: req_rsp
        end_idx: -1
        act: rsp
        suffix: req
        default: tlul_pkg::TL_H2D_DEFAULT
      }
      {
        package: tlul_pkg
        struct: tl_d2h
        domain: Aon
        signame: clkmgr_tl_rsp
        width: 1
        type: req_rsp
        end_idx: -1
        act: rsp
        suffix: rsp
        default: ""
      }
      {
        package: tlul_pkg
        struct: tl_h2d
        domain: Aon
        signame: alert_handler_tl_req
        width: 1
        type: req_rsp
        end_idx: -1
        act: rsp
        suffix: req
        default: tlul_pkg::TL_H2D_DEFAULT
      }
      {
        package: tlul_pkg
        struct: tl_d2h
        domain: Aon
        signame: alert_handler_tl_rsp
        width: 1
        type: req_rsp
        end_idx: -1
        act: rsp
        suffix: rsp
        default: ""
      }
      {
        package: tlul_pkg
        struct: tl_h2d
        domain: Aon
        signame: rv_timer_aon_tl_req
        width: 1
        type: req_rsp
        end_idx: -1
        act: rsp
        suffix: req
        default: tlul_pkg::TL_H2D_DEFAULT
      }
      {
        package: tlul_pkg
        struct: tl_d2h
        domain: Aon
        signame: rv_timer_aon_tl_rsp
        width: 1
        type: req_rsp
        end_idx: -1
        act: rsp
        suffix: rsp
        default: ""
      }
      {
        package: tlul_pkg
        struct: tl_h2d
        domain: Aon
        signame: sram_ctrl_ret_aon_regs_tl_req
        width: 1
        type: req_rsp
        end_idx: -1
        act: rsp
        suffix: req
        default: tlul_pkg::TL_H2D_DEFAULT
      }
      {
        package: tlul_pkg
        struct: tl_d2h
        domain: Aon
        signame: sram_ctrl_ret_aon_regs_tl_rsp
        width: 1
        type: req_rsp
        end_idx: -1
        act: rsp
        suffix: rsp
        default: ""
      }
      {
        package: tlul_pkg
        struct: tl_h2d
        domain: Aon
        signame: sram_ctrl_ret_aon_ram_tl_req
        width: 1
        type: req_rsp
        end_idx: -1
        act: rsp
        suffix: req
        default: tlul_pkg::TL_H2D_DEFAULT
      }
      {
        package: tlul_pkg
        struct: tl_d2h
        domain: Aon
        signame: sram_ctrl_ret_aon_ram_tl_rsp
        width: 1
        type: req_rsp
        end_idx: -1
        act: rsp
        suffix: rsp
        default: ""
      }
      {
        package: tlul_pkg
        struct: tl_h2d
        domain: Main
        signame: socmbx_tl_ahb_bridge__socmbx_req
        width: 1
        type: req_rsp
        end_idx: -1
        act: rsp
        suffix: req
        default: tlul_pkg::TL_H2D_DEFAULT
      }
      {
        package: tlul_pkg
        struct: tl_d2h
        domain: Main
        signame: socmbx_tl_ahb_bridge__socmbx_rsp
        width: 1
        type: req_rsp
        end_idx: -1
        act: rsp
        suffix: rsp
        default: ""
      }
      {
        package: tlul_pkg
        struct: tl_h2d
        domain: Main
        signame: mbx0_soc_tl_d_req
        width: 1
        type: req_rsp
        end_idx: -1
        act: rsp
        suffix: req
        default: tlul_pkg::TL_H2D_DEFAULT
      }
      {
        package: tlul_pkg
        struct: tl_d2h
        domain: Main
        signame: mbx0_soc_tl_d_rsp
        width: 1
        type: req_rsp
        end_idx: -1
        act: rsp
        suffix: rsp
        default: ""
      }
      {
        package: tlul_pkg
        struct: tl_h2d
        domain: Main
        signame: mbx1_soc_tl_d_req
        width: 1
        type: req_rsp
        end_idx: -1
        act: rsp
        suffix: req
        default: tlul_pkg::TL_H2D_DEFAULT
      }
      {
        package: tlul_pkg
        struct: tl_d2h
        domain: Main
        signame: mbx1_soc_tl_d_rsp
        width: 1
        type: req_rsp
        end_idx: -1
        act: rsp
        suffix: rsp
        default: ""
      }
      {
        package: tlul_pkg
        struct: tl_h2d
        domain: Main
        signame: lc_ctrl_dmi_tl_req
        width: 1
        type: req_rsp
        end_idx: -1
        act: rsp
        suffix: req
        default: tlul_pkg::TL_H2D_DEFAULT
      }
      {
        package: tlul_pkg
        struct: tl_d2h
        domain: Main
        signame: lc_ctrl_dmi_tl_rsp
        width: 1
        type: req_rsp
        end_idx: -1
        act: rsp
        suffix: rsp
        default: ""
      }
      {
        package: tlul_pkg
        struct: tl_h2d
        domain: Main
        signame: rv_dm_dbg_tl_d_req
        width: 1
        type: req_rsp
        end_idx: -1
        act: rsp
        suffix: req
        default: tlul_pkg::TL_H2D_DEFAULT
      }
      {
        package: tlul_pkg
        struct: tl_d2h
        domain: Main
        signame: rv_dm_dbg_tl_d_rsp
        width: 1
        type: req_rsp
        end_idx: -1
        act: rsp
        suffix: rsp
        default: ""
      }
      {
        package: clkmgr_pkg
        struct: clkmgr_out
        signame: clkmgr_clocks
        domain: Aon
        width: 1
        type: uni
        end_idx: -1
        default: ""
      }
      {
        package: clkmgr_pkg
        struct: clkmgr_cg_en
        signame: clkmgr_cg_en
        domain: Aon
        width: 1
        type: uni
        end_idx: -1
        default: ""
      }
      {
        package: rstmgr_pkg
        struct: rstmgr_out
        signame: rstmgr_resets
        domain: Aon
        width: 1
        type: uni
        end_idx: -1
        default: ""
      }
      {
        package: rstmgr_pkg
        struct: rstmgr_rst_en
        signame: rstmgr_rst_en
        domain: Aon
        width: 1
        type: uni
        end_idx: -1
        default: ""
      }
      {
        package: ""
        struct: logic
        signame: rstmgr_por_n
        domain: Aon
        width: 2
        type: uni
        end_idx: -1
        default: ""
      }
      {
        package: pwrmgr_pkg
        struct: pwr_ast_req
        domain: Aon
        signame: pwrmgr_pwr_ast_req
        width: 1
        type: req_rsp
        end_idx: -1
        default: ""
      }
      {
        package: pwrmgr_pkg
        struct: pwr_ast_rsp
        domain: Aon
        signame: pwrmgr_pwr_ast_rsp
        width: 1
        type: req_rsp
        end_idx: -1
        default: ""
      }
      {
        package: lc_ctrl_pkg
        struct: lc_tx
        signame: lc_ctrl_lc_nvm_debug_en
        domain: Main
        width: 1
        type: uni
        end_idx: -1
        default: lc_ctrl_pkg::Off
      }
      {
        package: ""
        struct: logic
        signame: rv_core_ibex_irq_timer
        domain: Main
        width: 1
        type: uni
        end_idx: -1
        default: ""
      }
      {
        package: ""
        struct: logic
        signame: rv_core_ibex_hart_id
        domain: Main
        width: 32
        type: uni
        end_idx: -1
        default: ""
      }
      {
        package: ""
        struct: logic
        signame: rv_core_ibex_boot_addr
        domain: Main
        width: 32
        type: uni
        end_idx: -1
        default: ""
      }
      {
        package: otp_ctrl_part_pkg
        struct: otp_broadcast
        signame: otp_ctrl_otp_broadcast
        domain: Main
        width: 1
        type: uni
        end_idx: -1
        default: "'0"
      }
      {
        package: prim_mubi_pkg
        struct: mubi8
        signame: csrng_otp_en_csrng_sw_app_read
        domain: Main
        width: 1
        type: uni
        end_idx: -1
        default: prim_mubi_pkg::MuBi8True
      }
      {
        package: otp_ctrl_pkg
        struct: otp_device_id
        signame: lc_ctrl_otp_device_id
        domain: Main
        width: 1
        type: uni
        end_idx: -1
        default: "'0"
      }
      {
        package: otp_ctrl_pkg
        struct: otp_manuf_state
        signame: lc_ctrl_otp_manuf_state
        domain: Main
        width: 1
        type: uni
        end_idx: -1
        default: "'0"
      }
      {
        package: keymgr_dpe_pkg
        struct: keymgr_dpe_device_id
        signame: keymgr_dpe_device_id
        domain: Main
        width: 1
        type: uni
        end_idx: -1
        default: ""
      }
      {
        package: prim_mubi_pkg
        struct: mubi8
        signame: sram_ctrl_main_otp_en_sram_ifetch
        domain: Main
        width: 1
        type: uni
        end_idx: -1
        default: prim_mubi_pkg::MuBi8False
      }
      {
        package: prim_mubi_pkg
        struct: mubi8
        signame: rv_dm_otp_dis_rv_dm_late_debug
        domain: Main
        width: 1
        type: uni
        end_idx: -1
        default: prim_mubi_pkg::MuBi8False
      }
    ]
  }
}
